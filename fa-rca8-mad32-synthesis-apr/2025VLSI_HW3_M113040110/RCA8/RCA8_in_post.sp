************************************************************************
* auCdl Netlist:
*
* Library Name:  Homwork3
* Top Cell Name: RCA8
* View Name:     schematic
* Netlisted on:  May  8 19:29:24 2023
************************************************************************

*.BIPOLAR
*.RESI = 2000
*.RESVAL
*.CAPVAL
*.DIOPERI
*.DIOAREA
*.EQUATION
*.SCALE METER
*.MEGA
*.PARAM

.GLOBAL gnd!
+        vdd!
+        GND!

*.PIN gnd!
*+    vdd!
*+    GND!

************************************************************************
* Library Name: Homwork3
* Cell Name:    INV_X2
* View Name:    schematic
************************************************************************

.SUBCKT INV_X2 in out
*.PININFO in:I out:O
MM0 out in vdd! vdd! P_18 W=1.00u L=180.00n
MM1 out in gnd! gnd! N_18 W=500.00n L=180.00n
.ENDS

************************************************************************
* Library Name: Homwork3
* Cell Name:    NAND_X1
* View Name:    schematic
************************************************************************

.SUBCKT NAND_X1 A B out
*.PININFO A:I B:I out:O
MM0 out A vdd! vdd! P_18 W=500.00n L=180.00n
MM1 out B vdd! vdd! P_18 W=500.00n L=180.00n
MM2 out A net13 gnd! N_18 W=500.00n L=180.00n
MM3 net13 B gnd! gnd! N_18 W=500.00n L=180.00n
.ENDS

************************************************************************
* Library Name: Homwork3
* Cell Name:    NAND_X2
* View Name:    schematic
************************************************************************

.SUBCKT NAND_X2 A B out
*.PININFO A:I B:I out:O
MM0 out A vdd! vdd! P_18 W=1.00u L=180.00n
MM1 out B vdd! vdd! P_18 W=1.00u L=180.00n
MM2 out A net11 gnd! N_18 W=1.00u L=180.00n
MM3 net11 B gnd! gnd! N_18 W=1.00u L=180.00n
.ENDS

************************************************************************
* Library Name: Homwork3
* Cell Name:    RCA8_DW01_add_0
* View Name:    schematic
************************************************************************

.SUBCKT RCA8_DW01_add_0 A[8] A[7] A[6] A[5] A[4] A[3] A[2] A[1] A[0] B[8] B[7]
+ B[6] B[5] B[4] B[3] B[2] B[1] B[0] CI CO SUM[8] SUM[7] SUM[6] SUM[5] SUM[4]
+ SUM[3] SUM[2] SUM[1] SUM[0]
*.PININFO A[8]:I A[7]:I A[6]:I A[5]:I A[4]:I A[3]:I A[2]:I A[1]:I A[0]:I
*.PININFO B[8]:I B[7]:I B[6]:I B[5]:I B[4]:I B[3]:I B[2]:I B[1]:I B[0]:I CI:I
*.PININFO CO:O SUM[8]:O SUM[7]:O SUM[6]:O SUM[5]:O SUM[4]:O SUM[3]:O SUM[2]:O
*.PININFO SUM[1]:O SUM[0]:O
XU105 n107 n181 / INV_X2
XU104 n104 SUM[1] / INV_X2
XU101 n97 n177 / INV_X2
XU100 n94 SUM[2] / INV_X2
XU97 n87 n173 / INV_X2
XU96 n84 SUM[3] / INV_X2
XU93 n77 n169 / INV_X2
XU92 n74 SUM[4] / INV_X2
XU89 n67 n165 / INV_X2
XU88 n64 SUM[5] / INV_X2
XU85 n57 n161 / INV_X2
XU84 n54 SUM[6] / INV_X2
XU81 n44 SUM[7] / INV_X2
XU82 n47 n158 / INV_X2
XU117 n115 n193 / INV_X2
XU119 CI n195 / INV_X2
XU116 B[1] n192 / INV_X2
XU115 B[2] n191 / INV_X2
XU114 B[3] n190 / INV_X2
XU113 B[4] n189 / INV_X2
XU112 B[5] n188 / INV_X2
XU111 B[6] n187 / INV_X2
XU110 B[7] n186 / INV_X2
XU109 A[0] n185 / INV_X2
XU118 B[0] n194 / INV_X2
XU107 A[1] n183 / INV_X2
XU108 n101 n184 / INV_X2
XU103 A[2] n179 / INV_X2
XU106 n91 n182 / INV_X2
XU99 A[3] n175 / INV_X2
XU102 n81 n178 / INV_X2
XU95 A[4] n171 / INV_X2
XU98 n71 n174 / INV_X2
XU91 A[5] n167 / INV_X2
XU94 n61 n170 / INV_X2
XU87 A[6] n163 / INV_X2
XU90 n51 n166 / INV_X2
XU83 A[7] n159 / INV_X2
XU86 n43 n162 / INV_X2
XU11 n181 n184 n106 / NAND_X1
XU10 n107 n101 n105 / NAND_X1
XU9 n105 n106 n104 / NAND_X1
XU13 n97 n91 n95 / NAND_X1
XU14 n177 n182 n96 / NAND_X1
XU12 n95 n96 n94 / NAND_X1
XU17 n173 n178 n86 / NAND_X1
XU16 n87 n81 n85 / NAND_X1
XU15 n85 n86 n84 / NAND_X1
XU20 n169 n174 n76 / NAND_X1
XU19 n77 n71 n75 / NAND_X1
XU18 n75 n76 n74 / NAND_X1
XU22 n67 n61 n65 / NAND_X1
XU23 n165 n170 n66 / NAND_X1
XU21 n65 n66 n64 / NAND_X1
XU8 n161 n166 n56 / NAND_X1
XU7 n57 n51 n55 / NAND_X1
XU6 n55 n56 n54 / NAND_X1
XU25 n47 n43 n45 / NAND_X1
XU26 n158 n162 n46 / NAND_X1
XU24 n45 n46 n44 / NAND_X1
XU80 n193 A[0] n114 / NAND_X1
XU78 n113 n114 SUM[0] / NAND_X1
XU79 n115 n185 n113 / NAND_X1
XU75 n116 n117 n115 / NAND_X1
XU76 CI n194 n117 / NAND_X1
XU77 B[0] n195 n116 / NAND_X1
XU70 n194 n185 n110 / NAND_X1
XU69 CI n110 n109 / NAND_X1
XU67 n108 n109 n101 / NAND_X1
XU68 B[0] A[0] n108 / NAND_X1
XU45 A[1] n192 n111 / NAND_X1
XU43 n111 n112 n107 / NAND_X1
XU44 B[1] n183 n112 / NAND_X1
XU66 n184 n183 n100 / NAND_X1
XU65 B[1] n100 n99 / NAND_X1
XU64 A[1] n101 n98 / NAND_X1
XU1 n98 n99 n91 / NAND_X1
XU48 A[2] n191 n102 / NAND_X1
XU46 n102 n103 n97 / NAND_X1
XU47 B[2] n179 n103 / NAND_X1
XU30 n182 n179 n90 / NAND_X1
XU29 B[2] n90 n89 / NAND_X1
XU27 n88 n89 n81 / NAND_X1
XU28 A[2] n91 n88 / NAND_X1
XU51 A[3] n190 n92 / NAND_X1
XU49 n92 n93 n87 / NAND_X1
XU50 B[3] n175 n93 / NAND_X1
XU33 n178 n175 n80 / NAND_X1
XU32 B[3] n80 n79 / NAND_X1
XU31 A[3] n81 n78 / NAND_X1
XU54 A[4] n189 n82 / NAND_X1
XU52 n82 n83 n77 / NAND_X1
XU53 B[4] n171 n83 / NAND_X1
XU3 n174 n171 n70 / NAND_X1
XU35 B[4] n70 n69 / NAND_X1
XU34 A[4] n71 n68 / NAND_X1
XU2 n68 n69 n61 / NAND_X1
XU57 A[5] n188 n72 / NAND_X1
XU55 n72 n73 n67 / NAND_X1
XU56 B[5] n167 n73 / NAND_X1
XU39 n170 n167 n60 / NAND_X1
XU38 B[5] n60 n59 / NAND_X1
XU36 n58 n59 n51 / NAND_X1
XU37 A[5] n61 n58 / NAND_X1
XU60 A[6] n187 n62 / NAND_X1
XU58 n62 n63 n57 / NAND_X1
XU59 B[6] n163 n63 / NAND_X1
XU42 n166 n163 n50 / NAND_X1
XU41 B[6] n50 n49 / NAND_X1
XU40 A[6] n51 n48 / NAND_X1
XU4 n48 n49 n43 / NAND_X1
XU63 A[7] n186 n52 / NAND_X1
XU61 n52 n53 n47 / NAND_X1
XU62 B[7] n159 n53 / NAND_X1
XU72 A[7] n43 n40 / NAND_X1
XU71 n40 n41 SUM[8] / NAND_X1
XU73 B[7] n42 n41 / NAND_X1
XU74 n162 n159 n42 / NAND_X1
XU5 n78 n79 n71 / NAND_X2
.ENDS

************************************************************************
* Library Name: Homwork3
* Cell Name:    RCA8
* View Name:    schematic
************************************************************************

* File: RCA8.pex.sp
* Created: Tue May  9 11:23:42 2023
* Program "Calibre xRC"
* Version "v2018.2_24.18"
*
.include "RCA8.pex.sp.pex"
.subckt RCA8  GND! VDD! CIN A[3] SUM[7] B[5] A[6] B[6] A[5] A[7] SUM[4] SUM[6]
+ B[7] B[3] SUM[1] A[0] B[2] B[1] A[2] A[1] SUM[0] SUM[2] SUM[5] B[4] A[4] COUT
+ B[0] SUM[3]
*
* SUM[3]	SUM[3]
* B[0]	B[0]
* COUT	COUT
* A[4]	A[4]
* B[4]	B[4]
* SUM[5]	SUM[5]
* SUM[2]	SUM[2]
* SUM[0]	SUM[0]
* A[1]	A[1]
* A[2]	A[2]
* B[1]	B[1]
* B[2]	B[2]
* A[0]	A[0]
* SUM[1]	SUM[1]
* B[3]	B[3]
* B[7]	B[7]
* SUM[6]	SUM[6]
* SUM[4]	SUM[4]
* A[7]	A[7]
* A[5]	A[5]
* B[6]	B[6]
* A[6]	A[6]
* B[5]	B[5]
* SUM[7]	SUM[7]
* A[3]	A[3]
* CIN	CIN
* VDD!	VDD!
* GND!	GND!
M0 N_139_M0_d N_15_M0_g N_25_M0_s N_GND!_X26/M0_b N_18 L=1.8e-07 W=1e-06
+ AD=2.975e-13 AS=5.15e-13 PD=5.95e-07 PS=2.03e-06
M1 N_GND!_M1_d N_85_M1_g N_139_M1_s N_GND!_X26/M0_b N_18 L=1.8e-07 W=1e-06
+ AD=5.35e-13 AS=2.975e-13 PD=2.07e-06 PS=5.95e-07
M2 N_25_M2_d N_15_M2_g N_VDD!_M2_s N_VDD!_X30/M1_b P_18 L=1.8e-07 W=1e-06
+ AD=2.975e-13 AS=5.15e-13 PD=5.95e-07 PS=2.03e-06
M3 N_VDD!_M3_d N_85_M3_g N_25_M3_s N_VDD!_X30/M1_b P_18 L=1.8e-07 W=1e-06
+ AD=5.35e-13 AS=2.975e-13 PD=2.07e-06 PS=5.95e-07
mX26/M0 N_SUM[7]_X26/M0_d N_126_X26/M0_g N_GND!_X26/M0_s N_GND!_X26/M0_b N_18
+ L=1.8e-07 W=5e-07 AD=3.525e-13 AS=3.475e-13 PD=1.91e-06 PS=1.89e-06
mX26/M1 N_SUM[7]_X26/M1_d N_126_X26/M1_g N_VDD!_X26/M1_s N_VDD!_X26/M1_b P_18
+ L=1.8e-07 W=1e-06 AD=4.9e-13 AS=4.9e-13 PD=1.98e-06 PS=1.98e-06
mX27/M0 N_SUM[5]_X27/M0_d N_78_X27/M0_g N_GND!_X27/M0_s N_GND!_X26/M0_b N_18
+ L=1.8e-07 W=5e-07 AD=3.525e-13 AS=3.475e-13 PD=1.91e-06 PS=1.89e-06
mX27/M1 N_SUM[5]_X27/M1_d N_78_X27/M1_g N_VDD!_X27/M1_s N_VDD!_X27/M1_b P_18
+ L=1.8e-07 W=1e-06 AD=4.9e-13 AS=4.9e-13 PD=1.98e-06 PS=1.98e-06
mX28/M0 N_128_X28/M0_d N_12_X28/M0_g N_GND!_X28/M0_s N_GND!_X26/M0_b N_18
+ L=1.8e-07 W=5e-07 AD=3.525e-13 AS=3.475e-13 PD=1.91e-06 PS=1.89e-06
mX28/M1 N_128_X28/M1_d N_12_X28/M1_g N_VDD!_X28/M1_s N_VDD!_X28/M1_b P_18
+ L=1.8e-07 W=1e-06 AD=4.9e-13 AS=4.9e-13 PD=1.98e-06 PS=1.98e-06
mX29/M0 N_9_X29/M0_d N_B[5]_X29/M0_g N_GND!_X29/M0_s N_GND!_X26/M0_b N_18
+ L=1.8e-07 W=5e-07 AD=3.525e-13 AS=3.475e-13 PD=1.91e-06 PS=1.89e-06
mX29/M1 N_9_X29/M1_d N_B[5]_X29/M1_g N_VDD!_X29/M1_s N_VDD!_X28/M1_b P_18
+ L=1.8e-07 W=1e-06 AD=4.9e-13 AS=4.9e-13 PD=1.98e-06 PS=1.98e-06
mX30/M0 N_76_X30/M0_d N_B[6]_X30/M0_g N_GND!_X30/M0_s N_GND!_X26/M0_b N_18
+ L=1.8e-07 W=5e-07 AD=3.525e-13 AS=3.475e-13 PD=1.91e-06 PS=1.89e-06
mX30/M1 N_76_X30/M1_d N_B[6]_X30/M1_g N_VDD!_X30/M1_s N_VDD!_X30/M1_b P_18
+ L=1.8e-07 W=1e-06 AD=4.9e-13 AS=4.9e-13 PD=1.98e-06 PS=1.98e-06
mX31/M0 N_82_X31/M0_d N_87_X31/M0_g N_GND!_X31/M0_s N_GND!_X26/M0_b N_18
+ L=1.8e-07 W=5e-07 AD=3.525e-13 AS=3.475e-13 PD=1.91e-06 PS=1.89e-06
mX31/M1 N_82_X31/M1_d N_87_X31/M1_g N_VDD!_X31/M1_s N_VDD!_X28/M1_b P_18
+ L=1.8e-07 W=1e-06 AD=4.9e-13 AS=4.9e-13 PD=1.98e-06 PS=1.98e-06
mX32/M0 N_83_X32/M0_d N_25_X32/M0_g N_GND!_X32/M0_s N_GND!_X26/M0_b N_18
+ L=1.8e-07 W=5e-07 AD=3.525e-13 AS=3.475e-13 PD=1.91e-06 PS=1.89e-06
mX32/M1 N_83_X32/M1_d N_25_X32/M1_g N_VDD!_X32/M1_s N_VDD!_X26/M1_b P_18
+ L=1.8e-07 W=1e-06 AD=4.9e-13 AS=4.9e-13 PD=1.98e-06 PS=1.98e-06
mX33/M0 N_10_X33/M0_d N_A[5]_X33/M0_g N_GND!_X33/M0_s N_GND!_X26/M0_b N_18
+ L=1.8e-07 W=5e-07 AD=3.525e-13 AS=3.475e-13 PD=1.91e-06 PS=1.89e-06
mX33/M1 N_10_X33/M1_d N_A[5]_X33/M1_g N_VDD!_X33/M1_s N_VDD!_X33/M1_b P_18
+ L=1.8e-07 W=1e-06 AD=4.9e-13 AS=4.9e-13 PD=1.98e-06 PS=1.98e-06
mX34/M0 N_16_X34/M0_d N_A[6]_X34/M0_g N_GND!_X34/M0_s N_GND!_X26/M0_b N_18
+ L=1.8e-07 W=5e-07 AD=3.525e-13 AS=3.475e-13 PD=1.91e-06 PS=1.89e-06
mX34/M1 N_16_X34/M1_d N_A[6]_X34/M1_g N_VDD!_X34/M1_s N_VDD!_X30/M1_b P_18
+ L=1.8e-07 W=1e-06 AD=4.9e-13 AS=4.9e-13 PD=1.98e-06 PS=1.98e-06
mX35/M0 N_131_X35/M0_d N_13_X35/M0_g N_GND!_X35/M0_s N_GND!_X26/M0_b N_18
+ L=1.8e-07 W=5e-07 AD=3.525e-13 AS=3.475e-13 PD=1.91e-06 PS=1.89e-06
mX35/M1 N_131_X35/M1_d N_13_X35/M1_g N_VDD!_X35/M1_s N_VDD!_X26/M1_b P_18
+ L=1.8e-07 W=1e-06 AD=4.9e-13 AS=4.9e-13 PD=1.98e-06 PS=1.98e-06
mX36/M0 N_28_X36/M0_d N_B[4]_X36/M0_g N_GND!_X36/M0_s N_GND!_X26/M0_b N_18
+ L=1.8e-07 W=5e-07 AD=3.525e-13 AS=3.475e-13 PD=1.91e-06 PS=1.89e-06
mX36/M1 N_28_X36/M1_d N_B[4]_X36/M1_g N_VDD!_X36/M1_s N_VDD!_X27/M1_b P_18
+ L=1.8e-07 W=1e-06 AD=4.9e-13 AS=4.9e-13 PD=1.98e-06 PS=1.98e-06
mX37/M0 N_30_X37/M0_d N_21_X37/M0_g N_GND!_X37/M0_s N_GND!_X26/M0_b N_18
+ L=1.8e-07 W=5e-07 AD=3.525e-13 AS=3.475e-13 PD=1.91e-06 PS=1.89e-06
mX37/M1 N_30_X37/M1_d N_21_X37/M1_g N_VDD!_X37/M1_s N_VDD!_X33/M1_b P_18
+ L=1.8e-07 W=1e-06 AD=4.9e-13 AS=4.9e-13 PD=1.98e-06 PS=1.98e-06
mX38/M0 N_93_X38/M0_d N_A[7]_X38/M0_g N_GND!_X38/M0_s N_GND!_X26/M0_b N_18
+ L=1.8e-07 W=5e-07 AD=3.525e-13 AS=3.475e-13 PD=1.91e-06 PS=1.89e-06
mX38/M1 N_93_X38/M1_d N_A[7]_X38/M1_g N_VDD!_X38/M1_s N_VDD!_X26/M1_b P_18
+ L=1.8e-07 W=1e-06 AD=4.9e-13 AS=4.9e-13 PD=1.98e-06 PS=1.98e-06
mX39/M0 N_133_X39/M0_d N_20_X39/M0_g N_GND!_X39/M0_s N_GND!_X26/M0_b N_18
+ L=1.8e-07 W=5e-07 AD=3.525e-13 AS=3.475e-13 PD=1.91e-06 PS=1.89e-06
mX39/M1 N_133_X39/M1_d N_20_X39/M1_g N_VDD!_X39/M1_s N_VDD!_X30/M1_b P_18
+ L=1.8e-07 W=1e-06 AD=4.9e-13 AS=4.9e-13 PD=1.98e-06 PS=1.98e-06
mX40/M0 N_91_X40/M0_d N_A[4]_X40/M0_g N_GND!_X40/M0_s N_GND!_X26/M0_b N_18
+ L=1.8e-07 W=5e-07 AD=3.525e-13 AS=3.475e-13 PD=1.91e-06 PS=1.89e-06
mX40/M1 N_91_X40/M1_d N_A[4]_X40/M1_g N_VDD!_X40/M1_s N_VDD!_X27/M1_b P_18
+ L=1.8e-07 W=1e-06 AD=4.9e-13 AS=4.9e-13 PD=1.98e-06 PS=1.98e-06
mX41/M0 N_SUM[4]_X41/M0_d N_96_X41/M0_g N_GND!_X41/M0_s N_GND!_X26/M0_b N_18
+ L=1.8e-07 W=5e-07 AD=3.525e-13 AS=3.475e-13 PD=1.91e-06 PS=1.89e-06
mX41/M1 N_SUM[4]_X41/M1_d N_96_X41/M1_g N_VDD!_X41/M1_s N_VDD!_X28/M1_b P_18
+ L=1.8e-07 W=1e-06 AD=4.9e-13 AS=4.9e-13 PD=1.98e-06 PS=1.98e-06
mX42/M0 N_92_X42/M0_d N_100_X42/M0_g N_GND!_X42/M0_s N_GND!_X26/M0_b N_18
+ L=1.8e-07 W=5e-07 AD=3.525e-13 AS=3.475e-13 PD=1.91e-06 PS=1.89e-06
mX42/M1 N_92_X42/M1_d N_100_X42/M1_g N_VDD!_X42/M1_s N_VDD!_X33/M1_b P_18
+ L=1.8e-07 W=1e-06 AD=4.9e-13 AS=4.9e-13 PD=1.98e-06 PS=1.98e-06
mX43/M0 N_95_X43/M0_d N_29_X43/M0_g N_GND!_X43/M0_s N_GND!_X26/M0_b N_18
+ L=1.8e-07 W=5e-07 AD=3.525e-13 AS=3.475e-13 PD=1.91e-06 PS=1.89e-06
mX43/M1 N_95_X43/M1_d N_29_X43/M1_g N_VDD!_X43/M1_s N_VDD!_X28/M1_b P_18
+ L=1.8e-07 W=1e-06 AD=4.9e-13 AS=4.9e-13 PD=1.98e-06 PS=1.98e-06
mX44/M0 N_SUM[6]_X44/M0_d N_34_X44/M0_g N_GND!_X44/M0_s N_GND!_X26/M0_b N_18
+ L=1.8e-07 W=5e-07 AD=3.525e-13 AS=3.475e-13 PD=1.91e-06 PS=1.89e-06
mX44/M1 N_SUM[6]_X44/M1_d N_34_X44/M1_g N_VDD!_X44/M1_s N_VDD!_X33/M1_b P_18
+ L=1.8e-07 W=1e-06 AD=4.9e-13 AS=4.9e-13 PD=1.98e-06 PS=1.98e-06
mX45/M0 N_32_X45/M0_d N_B[7]_X45/M0_g N_GND!_X45/M0_s N_GND!_X26/M0_b N_18
+ L=1.8e-07 W=5e-07 AD=3.525e-13 AS=3.475e-13 PD=1.91e-06 PS=1.89e-06
mX45/M1 N_32_X45/M1_d N_B[7]_X45/M1_g N_VDD!_X45/M1_s N_VDD!_X26/M1_b P_18
+ L=1.8e-07 W=1e-06 AD=4.9e-13 AS=4.9e-13 PD=1.98e-06 PS=1.98e-06
mX46/M0 N_SUM[2]_X46/M0_d N_104_X46/M0_g N_GND!_X46/M0_s N_GND!_X26/M0_b N_18
+ L=1.8e-07 W=5e-07 AD=3.525e-13 AS=3.475e-13 PD=1.91e-06 PS=1.89e-06
mX46/M1 N_SUM[2]_X46/M1_d N_104_X46/M1_g N_VDD!_X46/M1_s N_VDD!_X33/M1_b P_18
+ L=1.8e-07 W=1e-06 AD=4.9e-13 AS=4.9e-13 PD=1.98e-06 PS=1.98e-06
mX47/M0 N_41_X47/M0_d N_CIN_X47/M0_g N_GND!_X47/M0_s N_GND!_X26/M0_b N_18
+ L=1.8e-07 W=5e-07 AD=3.525e-13 AS=3.475e-13 PD=1.91e-06 PS=1.89e-06
mX47/M1 N_41_X47/M1_d N_CIN_X47/M1_g N_VDD!_X47/M1_s N_VDD!_X26/M1_b P_18
+ L=1.8e-07 W=1e-06 AD=4.9e-13 AS=4.9e-13 PD=1.98e-06 PS=1.98e-06
mX48/M0 N_46_X48/M0_d N_55_X48/M0_g N_GND!_X48/M0_s N_GND!_X26/M0_b N_18
+ L=1.8e-07 W=5e-07 AD=3.525e-13 AS=3.475e-13 PD=1.91e-06 PS=1.89e-06
mX48/M1 N_46_X48/M1_d N_55_X48/M1_g N_VDD!_X48/M1_s N_VDD!_X30/M1_b P_18
+ L=1.8e-07 W=1e-06 AD=4.9e-13 AS=4.9e-13 PD=1.98e-06 PS=1.98e-06
mX49/M0 N_SUM[1]_X49/M0_d N_105_X49/M0_g N_GND!_X49/M0_s N_GND!_X26/M0_b N_18
+ L=1.8e-07 W=5e-07 AD=3.525e-13 AS=3.475e-13 PD=1.91e-06 PS=1.89e-06
mX49/M1 N_SUM[1]_X49/M1_d N_105_X49/M1_g N_VDD!_X49/M1_s N_VDD!_X30/M1_b P_18
+ L=1.8e-07 W=1e-06 AD=4.9e-13 AS=4.9e-13 PD=1.98e-06 PS=1.98e-06
mX50/M0 N_106_X50/M0_d N_B[3]_X50/M0_g N_GND!_X50/M0_s N_GND!_X26/M0_b N_18
+ L=1.8e-07 W=5e-07 AD=3.525e-13 AS=3.475e-13 PD=1.91e-06 PS=1.89e-06
mX50/M1 N_106_X50/M1_d N_B[3]_X50/M1_g N_VDD!_X50/M1_s N_VDD!_X28/M1_b P_18
+ L=1.8e-07 W=1e-06 AD=4.9e-13 AS=4.9e-13 PD=1.98e-06 PS=1.98e-06
mX51/M0 N_42_X51/M0_d N_110_X51/M0_g N_GND!_X51/M0_s N_GND!_X26/M0_b N_18
+ L=1.8e-07 W=5e-07 AD=3.525e-13 AS=3.475e-13 PD=1.91e-06 PS=1.89e-06
mX51/M1 N_42_X51/M1_d N_110_X51/M1_g N_VDD!_X51/M1_s N_VDD!_X33/M1_b P_18
+ L=1.8e-07 W=1e-06 AD=4.9e-13 AS=4.9e-13 PD=1.98e-06 PS=1.98e-06
mX52/M0 N_112_X52/M0_d N_A[3]_X52/M0_g N_GND!_X52/M0_s N_GND!_X26/M0_b N_18
+ L=1.8e-07 W=5e-07 AD=3.525e-13 AS=3.475e-13 PD=1.91e-06 PS=1.89e-06
mX52/M1 N_112_X52/M1_d N_A[3]_X52/M1_g N_VDD!_X52/M1_s N_VDD!_X28/M1_b P_18
+ L=1.8e-07 W=1e-06 AD=4.9e-13 AS=4.9e-13 PD=1.98e-06 PS=1.98e-06
mX53/M0 N_48_X53/M0_d N_69_X53/M0_g N_GND!_X53/M0_s N_GND!_X26/M0_b N_18
+ L=1.8e-07 W=5e-07 AD=3.525e-13 AS=3.475e-13 PD=1.91e-06 PS=1.89e-06
mX53/M1 N_48_X53/M1_d N_69_X53/M1_g N_VDD!_X53/M1_s N_VDD!_X33/M1_b P_18
+ L=1.8e-07 W=1e-06 AD=4.9e-13 AS=4.9e-13 PD=1.98e-06 PS=1.98e-06
mX54/M0 N_54_X54/M0_d N_B[0]_X54/M0_g N_GND!_X54/M0_s N_GND!_X26/M0_b N_18
+ L=1.8e-07 W=5e-07 AD=3.525e-13 AS=3.475e-13 PD=1.91e-06 PS=1.89e-06
mX54/M1 N_54_X54/M1_d N_B[0]_X54/M1_g N_VDD!_X54/M1_s N_VDD!_X26/M1_b P_18
+ L=1.8e-07 W=1e-06 AD=4.9e-13 AS=4.9e-13 PD=1.98e-06 PS=1.98e-06
mX55/M0 N_137_X55/M0_d N_45_X55/M0_g N_GND!_X55/M0_s N_GND!_X26/M0_b N_18
+ L=1.8e-07 W=5e-07 AD=3.525e-13 AS=3.475e-13 PD=1.91e-06 PS=1.89e-06
mX55/M1 N_137_X55/M1_d N_45_X55/M1_g N_VDD!_X55/M1_s N_VDD!_X30/M1_b P_18
+ L=1.8e-07 W=1e-06 AD=4.9e-13 AS=4.9e-13 PD=1.98e-06 PS=1.98e-06
mX56/M0 N_58_X56/M0_d N_A[1]_X56/M0_g N_GND!_X56/M0_s N_GND!_X26/M0_b N_18
+ L=1.8e-07 W=5e-07 AD=3.525e-13 AS=3.475e-13 PD=1.91e-06 PS=1.89e-06
mX56/M1 N_58_X56/M1_d N_A[1]_X56/M1_g N_VDD!_X56/M1_s N_VDD!_X30/M1_b P_18
+ L=1.8e-07 W=1e-06 AD=4.9e-13 AS=4.9e-13 PD=1.98e-06 PS=1.98e-06
mX57/M0 N_64_X57/M0_d N_108_X57/M0_g N_GND!_X57/M0_s N_GND!_X26/M0_b N_18
+ L=1.8e-07 W=5e-07 AD=3.525e-13 AS=3.475e-13 PD=1.91e-06 PS=1.89e-06
mX57/M1 N_64_X57/M1_d N_108_X57/M1_g N_VDD!_X57/M1_s N_VDD!_X28/M1_b P_18
+ L=1.8e-07 W=1e-06 AD=4.9e-13 AS=4.9e-13 PD=1.98e-06 PS=1.98e-06
mX58/M0 N_114_X58/M0_d N_A[2]_X58/M0_g N_GND!_X58/M0_s N_GND!_X26/M0_b N_18
+ L=1.8e-07 W=5e-07 AD=3.525e-13 AS=3.475e-13 PD=1.91e-06 PS=1.89e-06
mX58/M1 N_114_X58/M1_d N_A[2]_X58/M1_g N_VDD!_X58/M1_s N_VDD!_X33/M1_b P_18
+ L=1.8e-07 W=1e-06 AD=4.9e-13 AS=4.9e-13 PD=1.98e-06 PS=1.98e-06
mX59/M0 N_113_X59/M0_d N_A[0]_X59/M0_g N_GND!_X59/M0_s N_GND!_X26/M0_b N_18
+ L=1.8e-07 W=5e-07 AD=3.525e-13 AS=3.475e-13 PD=1.91e-06 PS=1.89e-06
mX59/M1 N_113_X59/M1_d N_A[0]_X59/M1_g N_VDD!_X59/M1_s N_VDD!_X26/M1_b P_18
+ L=1.8e-07 W=1e-06 AD=4.9e-13 AS=4.9e-13 PD=1.98e-06 PS=1.98e-06
mX60/M0 N_118_X60/M0_d N_63_X60/M0_g N_GND!_X60/M0_s N_GND!_X26/M0_b N_18
+ L=1.8e-07 W=5e-07 AD=3.525e-13 AS=3.475e-13 PD=1.91e-06 PS=1.89e-06
mX60/M1 N_118_X60/M1_d N_63_X60/M1_g N_VDD!_X60/M1_s N_VDD!_X26/M1_b P_18
+ L=1.8e-07 W=1e-06 AD=4.9e-13 AS=4.9e-13 PD=1.98e-06 PS=1.98e-06
mX61/M0 N_119_X61/M0_d N_B[2]_X61/M0_g N_GND!_X61/M0_s N_GND!_X26/M0_b N_18
+ L=1.8e-07 W=5e-07 AD=3.525e-13 AS=3.475e-13 PD=1.91e-06 PS=1.89e-06
mX61/M1 N_119_X61/M1_d N_B[2]_X61/M1_g N_VDD!_X61/M1_s N_VDD!_X33/M1_b P_18
+ L=1.8e-07 W=1e-06 AD=4.9e-13 AS=4.9e-13 PD=1.98e-06 PS=1.98e-06
mX62/M0 N_125_X62/M0_d N_B[1]_X62/M0_g N_GND!_X62/M0_s N_GND!_X26/M0_b N_18
+ L=1.8e-07 W=5e-07 AD=3.525e-13 AS=3.475e-13 PD=1.91e-06 PS=1.89e-06
mX62/M1 N_125_X62/M1_d N_B[1]_X62/M1_g N_VDD!_X62/M1_s N_VDD!_X30/M1_b P_18
+ L=1.8e-07 W=1e-06 AD=4.9e-13 AS=4.9e-13 PD=1.98e-06 PS=1.98e-06
mX63/M0 N_SUM[3]_X63/M0_d N_121_X63/M0_g N_GND!_X63/M0_s N_GND!_X26/M0_b N_18
+ L=1.8e-07 W=5e-07 AD=3.525e-13 AS=3.475e-13 PD=1.91e-06 PS=1.89e-06
mX63/M1 N_SUM[3]_X63/M1_d N_121_X63/M1_g N_VDD!_X63/M1_s N_VDD!_X27/M1_b P_18
+ L=1.8e-07 W=1e-06 AD=4.9e-13 AS=4.9e-13 PD=1.98e-06 PS=1.98e-06
mX64/M0 N_138_X64/M0_d N_68_X64/M0_g N_GND!_X64/M0_s N_GND!_X26/M0_b N_18
+ L=1.8e-07 W=5e-07 AD=3.525e-13 AS=3.475e-13 PD=1.91e-06 PS=1.89e-06
mX64/M1 N_138_X64/M1_d N_68_X64/M1_g N_VDD!_X64/M1_s N_VDD!_X28/M1_b P_18
+ L=1.8e-07 W=1e-06 AD=4.9e-13 AS=4.9e-13 PD=1.98e-06 PS=1.98e-06
mX85/M0 N_X85/6_X85/M0_d N_128_X85/M0_g N_GND!_X85/M0_s N_GND!_X26/M0_b N_18
+ L=1.8e-07 W=5e-07 AD=1.4e-13 AS=2.85e-13 PD=5.6e-07 PS=1.64e-06
mX85/M1 N_79_X85/M1_d N_82_X85/M1_g N_X85/6_X85/M1_s N_GND!_X26/M0_b N_18
+ L=1.8e-07 W=5e-07 AD=3.025e-13 AS=1.4e-13 PD=1.71e-06 PS=5.6e-07
mX85/M2 N_79_X85/M2_d N_128_X85/M2_g N_VDD!_X85/M2_s N_VDD!_X28/M1_b P_18
+ L=1.8e-07 W=5e-07 AD=1.4e-13 AS=2.85e-13 PD=5.6e-07 PS=1.64e-06
mX85/M3 N_VDD!_X85/M3_d N_82_X85/M3_g N_79_X85/M3_s N_VDD!_X28/M1_b P_18
+ L=1.8e-07 W=5e-07 AD=3.025e-13 AS=1.4e-13 PD=1.71e-06 PS=5.6e-07
mX86/M0 N_X86/6_X86/M0_d N_13_X86/M0_g N_GND!_X86/M0_s N_GND!_X26/M0_b N_18
+ L=1.8e-07 W=5e-07 AD=1.4e-13 AS=2.85e-13 PD=5.6e-07 PS=1.64e-06
mX86/M1 N_8_X86/M1_d N_25_X86/M1_g N_X86/6_X86/M1_s N_GND!_X26/M0_b N_18
+ L=1.8e-07 W=5e-07 AD=3.025e-13 AS=1.4e-13 PD=1.71e-06 PS=5.6e-07
mX86/M2 N_8_X86/M2_d N_13_X86/M2_g N_VDD!_X86/M2_s N_VDD!_X26/M1_b P_18
+ L=1.8e-07 W=5e-07 AD=1.4e-13 AS=2.85e-13 PD=5.6e-07 PS=1.64e-06
mX86/M3 N_VDD!_X86/M3_d N_25_X86/M3_g N_8_X86/M3_s N_VDD!_X26/M1_b P_18
+ L=1.8e-07 W=5e-07 AD=3.025e-13 AS=1.4e-13 PD=1.71e-06 PS=5.6e-07
mX87/M0 N_X87/6_X87/M0_d N_B[5]_X87/M0_g N_GND!_X87/M0_s N_GND!_X26/M0_b N_18
+ L=1.8e-07 W=5e-07 AD=1.4e-13 AS=2.85e-13 PD=5.6e-07 PS=1.64e-06
mX87/M1 N_86_X87/M1_d N_81_X87/M1_g N_X87/6_X87/M1_s N_GND!_X26/M0_b N_18
+ L=1.8e-07 W=5e-07 AD=3.025e-13 AS=1.4e-13 PD=1.71e-06 PS=5.6e-07
mX87/M2 N_86_X87/M2_d N_B[5]_X87/M2_g N_VDD!_X87/M2_s N_VDD!_X33/M1_b P_18
+ L=1.8e-07 W=5e-07 AD=1.4e-13 AS=2.85e-13 PD=5.6e-07 PS=1.64e-06
mX87/M3 N_VDD!_X87/M3_d N_81_X87/M3_g N_86_X87/M3_s N_VDD!_X33/M1_b P_18
+ L=1.8e-07 W=5e-07 AD=3.025e-13 AS=1.4e-13 PD=1.71e-06 PS=5.6e-07
mX88/M0 N_X88/6_X88/M0_d N_A[6]_X88/M0_g N_GND!_X88/M0_s N_GND!_X26/M0_b N_18
+ L=1.8e-07 W=5e-07 AD=1.4e-13 AS=2.85e-13 PD=5.6e-07 PS=1.64e-06
mX88/M1 N_85_X88/M1_d N_21_X88/M1_g N_X88/6_X88/M1_s N_GND!_X26/M0_b N_18
+ L=1.8e-07 W=5e-07 AD=3.025e-13 AS=1.4e-13 PD=1.71e-06 PS=5.6e-07
mX88/M2 N_85_X88/M2_d N_A[6]_X88/M2_g N_VDD!_X88/M2_s N_VDD!_X30/M1_b P_18
+ L=1.8e-07 W=5e-07 AD=1.4e-13 AS=2.85e-13 PD=5.6e-07 PS=1.64e-06
mX88/M3 N_VDD!_X88/M3_d N_21_X88/M3_g N_85_X88/M3_s N_VDD!_X30/M1_b P_18
+ L=1.8e-07 W=5e-07 AD=3.025e-13 AS=1.4e-13 PD=1.71e-06 PS=5.6e-07
mX89/M0 N_X89/6_X89/M0_d N_88_X89/M0_g N_GND!_X89/M0_s N_GND!_X26/M0_b N_18
+ L=1.8e-07 W=5e-07 AD=1.4e-13 AS=2.85e-13 PD=5.6e-07 PS=1.64e-06
mX89/M1 N_21_X89/M1_d N_86_X89/M1_g N_X89/6_X89/M1_s N_GND!_X26/M0_b N_18
+ L=1.8e-07 W=5e-07 AD=3.025e-13 AS=1.4e-13 PD=1.71e-06 PS=5.6e-07
mX89/M2 N_21_X89/M2_d N_88_X89/M2_g N_VDD!_X89/M2_s N_VDD!_X33/M1_b P_18
+ L=1.8e-07 W=5e-07 AD=1.4e-13 AS=2.85e-13 PD=5.6e-07 PS=1.64e-06
mX89/M3 N_VDD!_X89/M3_d N_86_X89/M3_g N_21_X89/M3_s N_VDD!_X33/M1_b P_18
+ L=1.8e-07 W=5e-07 AD=3.025e-13 AS=1.4e-13 PD=1.71e-06 PS=5.6e-07
mX90/M0 N_X90/6_X90/M0_d N_B[6]_X90/M0_g N_GND!_X90/M0_s N_GND!_X26/M0_b N_18
+ L=1.8e-07 W=5e-07 AD=1.4e-13 AS=2.85e-13 PD=5.6e-07 PS=1.64e-06
mX90/M1 N_15_X90/M1_d N_19_X90/M1_g N_X90/6_X90/M1_s N_GND!_X26/M0_b N_18
+ L=1.8e-07 W=5e-07 AD=3.025e-13 AS=1.4e-13 PD=1.71e-06 PS=5.6e-07
mX90/M2 N_15_X90/M2_d N_B[6]_X90/M2_g N_VDD!_X90/M2_s N_VDD!_X30/M1_b P_18
+ L=1.8e-07 W=5e-07 AD=1.4e-13 AS=2.85e-13 PD=5.6e-07 PS=1.64e-06
mX90/M3 N_VDD!_X90/M3_d N_19_X90/M3_g N_15_X90/M3_s N_VDD!_X30/M1_b P_18
+ L=1.8e-07 W=5e-07 AD=3.025e-13 AS=1.4e-13 PD=1.71e-06 PS=5.6e-07
mX91/M0 N_X91/6_X91/M0_d N_A[5]_X91/M0_g N_GND!_X91/M0_s N_GND!_X26/M0_b N_18
+ L=1.8e-07 W=5e-07 AD=1.4e-13 AS=2.85e-13 PD=5.6e-07 PS=1.64e-06
mX91/M1 N_88_X91/M1_d N_87_X91/M1_g N_X91/6_X91/M1_s N_GND!_X26/M0_b N_18
+ L=1.8e-07 W=5e-07 AD=3.025e-13 AS=1.4e-13 PD=1.71e-06 PS=5.6e-07
mX91/M2 N_88_X91/M2_d N_A[5]_X91/M2_g N_VDD!_X91/M2_s N_VDD!_X33/M1_b P_18
+ L=1.8e-07 W=5e-07 AD=1.4e-13 AS=2.85e-13 PD=5.6e-07 PS=1.64e-06
mX91/M3 N_VDD!_X91/M3_d N_87_X91/M3_g N_88_X91/M3_s N_VDD!_X33/M1_b P_18
+ L=1.8e-07 W=5e-07 AD=3.025e-13 AS=1.4e-13 PD=1.71e-06 PS=5.6e-07
mX92/M0 N_X92/6_X92/M0_d N_132_X92/M0_g N_GND!_X92/M0_s N_GND!_X26/M0_b N_18
+ L=1.8e-07 W=5e-07 AD=1.4e-13 AS=2.85e-13 PD=5.6e-07 PS=1.64e-06
mX92/M1 N_13_X92/M1_d N_26_X92/M1_g N_X92/6_X92/M1_s N_GND!_X26/M0_b N_18
+ L=1.8e-07 W=5e-07 AD=3.025e-13 AS=1.4e-13 PD=1.71e-06 PS=5.6e-07
mX92/M2 N_13_X92/M2_d N_132_X92/M2_g N_VDD!_X92/M2_s N_VDD!_X26/M1_b P_18
+ L=1.8e-07 W=5e-07 AD=1.4e-13 AS=2.85e-13 PD=5.6e-07 PS=1.64e-06
mX92/M3 N_VDD!_X92/M3_d N_26_X92/M3_g N_13_X92/M3_s N_VDD!_X26/M1_b P_18
+ L=1.8e-07 W=5e-07 AD=3.025e-13 AS=1.4e-13 PD=1.71e-06 PS=5.6e-07
mX93/M0 N_X93/6_X93/M0_d N_A[7]_X93/M0_g N_GND!_X93/M0_s N_GND!_X26/M0_b N_18
+ L=1.8e-07 W=5e-07 AD=1.4e-13 AS=2.85e-13 PD=5.6e-07 PS=1.64e-06
mX93/M1 N_132_X93/M1_d N_32_X93/M1_g N_X93/6_X93/M1_s N_GND!_X26/M0_b N_18
+ L=1.8e-07 W=5e-07 AD=3.025e-13 AS=1.4e-13 PD=1.71e-06 PS=5.6e-07
mX93/M2 N_132_X93/M2_d N_A[7]_X93/M2_g N_VDD!_X93/M2_s N_VDD!_X26/M1_b P_18
+ L=1.8e-07 W=5e-07 AD=1.4e-13 AS=2.85e-13 PD=5.6e-07 PS=1.64e-06
mX93/M3 N_VDD!_X93/M3_d N_32_X93/M3_g N_132_X93/M3_s N_VDD!_X26/M1_b P_18
+ L=1.8e-07 W=5e-07 AD=3.025e-13 AS=1.4e-13 PD=1.71e-06 PS=5.6e-07
mX94/M0 N_X94/6_X94/M0_d N_20_X94/M0_g N_GND!_X94/M0_s N_GND!_X26/M0_b N_18
+ L=1.8e-07 W=5e-07 AD=1.4e-13 AS=2.85e-13 PD=5.6e-07 PS=1.64e-06
mX94/M1 N_36_X94/M1_d N_21_X94/M1_g N_X94/6_X94/M1_s N_GND!_X26/M0_b N_18
+ L=1.8e-07 W=5e-07 AD=3.025e-13 AS=1.4e-13 PD=1.71e-06 PS=5.6e-07
mX94/M2 N_36_X94/M2_d N_20_X94/M2_g N_VDD!_X94/M2_s N_VDD!_X30/M1_b P_18
+ L=1.8e-07 W=5e-07 AD=1.4e-13 AS=2.85e-13 PD=5.6e-07 PS=1.64e-06
mX94/M3 N_VDD!_X94/M3_d N_21_X94/M3_g N_36_X94/M3_s N_VDD!_X30/M1_b P_18
+ L=1.8e-07 W=5e-07 AD=3.025e-13 AS=1.4e-13 PD=1.71e-06 PS=5.6e-07
mX95/M0 N_X95/6_X95/M0_d N_95_X95/M0_g N_GND!_X95/M0_s N_GND!_X26/M0_b N_18
+ L=1.8e-07 W=5e-07 AD=1.4e-13 AS=2.85e-13 PD=5.6e-07 PS=1.64e-06
mX95/M1 N_89_X95/M1_d N_91_X95/M1_g N_X95/6_X95/M1_s N_GND!_X26/M0_b N_18
+ L=1.8e-07 W=5e-07 AD=3.025e-13 AS=1.4e-13 PD=1.71e-06 PS=5.6e-07
mX95/M2 N_89_X95/M2_d N_95_X95/M2_g N_VDD!_X95/M2_s N_VDD!_X28/M1_b P_18
+ L=1.8e-07 W=5e-07 AD=1.4e-13 AS=2.85e-13 PD=5.6e-07 PS=1.64e-06
mX95/M3 N_VDD!_X95/M3_d N_91_X95/M3_g N_89_X95/M3_s N_VDD!_X28/M1_b P_18
+ L=1.8e-07 W=5e-07 AD=3.025e-13 AS=1.4e-13 PD=1.71e-06 PS=5.6e-07
mX96/M0 N_X96/6_X96/M0_d N_B[4]_X96/M0_g N_GND!_X96/M0_s N_GND!_X26/M0_b N_18
+ L=1.8e-07 W=5e-07 AD=1.4e-13 AS=2.85e-13 PD=5.6e-07 PS=1.64e-06
mX96/M1 N_31_X96/M1_d N_91_X96/M1_g N_X96/6_X96/M1_s N_GND!_X26/M0_b N_18
+ L=1.8e-07 W=5e-07 AD=3.025e-13 AS=1.4e-13 PD=1.71e-06 PS=5.6e-07
mX96/M2 N_31_X96/M2_d N_B[4]_X96/M2_g N_VDD!_X96/M2_s N_VDD!_X28/M1_b P_18
+ L=1.8e-07 W=5e-07 AD=1.4e-13 AS=2.85e-13 PD=5.6e-07 PS=1.64e-06
mX96/M3 N_VDD!_X96/M3_d N_91_X96/M3_g N_31_X96/M3_s N_VDD!_X28/M1_b P_18
+ L=1.8e-07 W=5e-07 AD=3.025e-13 AS=1.4e-13 PD=1.71e-06 PS=5.6e-07
mX97/M0 N_X97/6_X97/M0_d N_92_X97/M0_g N_GND!_X97/M0_s N_GND!_X26/M0_b N_18
+ L=1.8e-07 W=5e-07 AD=1.4e-13 AS=2.85e-13 PD=5.6e-07 PS=1.64e-06
mX97/M1 N_94_X97/M1_d N_95_X97/M1_g N_X97/6_X97/M1_s N_GND!_X26/M0_b N_18
+ L=1.8e-07 W=5e-07 AD=3.025e-13 AS=1.4e-13 PD=1.71e-06 PS=5.6e-07
mX97/M2 N_94_X97/M2_d N_92_X97/M2_g N_VDD!_X97/M2_s N_VDD!_X33/M1_b P_18
+ L=1.8e-07 W=5e-07 AD=1.4e-13 AS=2.85e-13 PD=5.6e-07 PS=1.64e-06
mX97/M3 N_VDD!_X97/M3_d N_95_X97/M3_g N_94_X97/M3_s N_VDD!_X33/M1_b P_18
+ L=1.8e-07 W=5e-07 AD=3.025e-13 AS=1.4e-13 PD=1.71e-06 PS=5.6e-07
mX98/M0 N_X98/6_X98/M0_d N_B[7]_X98/M0_g N_GND!_X98/M0_s N_GND!_X26/M0_b N_18
+ L=1.8e-07 W=5e-07 AD=1.4e-13 AS=2.85e-13 PD=5.6e-07 PS=1.64e-06
mX98/M1 N_26_X98/M1_d N_93_X98/M1_g N_X98/6_X98/M1_s N_GND!_X26/M0_b N_18
+ L=1.8e-07 W=5e-07 AD=3.025e-13 AS=1.4e-13 PD=1.71e-06 PS=5.6e-07
mX98/M2 N_26_X98/M2_d N_B[7]_X98/M2_g N_VDD!_X98/M2_s N_VDD!_X26/M1_b P_18
+ L=1.8e-07 W=5e-07 AD=1.4e-13 AS=2.85e-13 PD=5.6e-07 PS=1.64e-06
mX98/M3 N_VDD!_X98/M3_d N_93_X98/M3_g N_26_X98/M3_s N_VDD!_X26/M1_b P_18
+ L=1.8e-07 W=5e-07 AD=3.025e-13 AS=1.4e-13 PD=1.71e-06 PS=5.6e-07
mX99/M0 N_X99/6_X99/M0_d N_A[4]_X99/M0_g N_GND!_X99/M0_s N_GND!_X26/M0_b N_18
+ L=1.8e-07 W=5e-07 AD=1.4e-13 AS=2.85e-13 PD=5.6e-07 PS=1.64e-06
mX99/M1 N_101_X99/M1_d N_28_X99/M1_g N_X99/6_X99/M1_s N_GND!_X26/M0_b N_18
+ L=1.8e-07 W=5e-07 AD=3.025e-13 AS=1.4e-13 PD=1.71e-06 PS=5.6e-07
mX99/M2 N_101_X99/M2_d N_A[4]_X99/M2_g N_VDD!_X99/M2_s N_VDD!_X27/M1_b P_18
+ L=1.8e-07 W=5e-07 AD=1.4e-13 AS=2.85e-13 PD=5.6e-07 PS=1.64e-06
mX99/M3 N_VDD!_X99/M3_d N_28_X99/M3_g N_101_X99/M3_s N_VDD!_X27/M1_b P_18
+ L=1.8e-07 W=5e-07 AD=3.025e-13 AS=1.4e-13 PD=1.71e-06 PS=5.6e-07
mX100/M0 N_X100/6_X100/M0_d N_133_X100/M0_g N_GND!_X100/M0_s N_GND!_X26/M0_b
+ N_18 L=1.8e-07 W=5e-07 AD=1.4e-13 AS=2.85e-13 PD=5.6e-07 PS=1.64e-06
mX100/M1 N_99_X100/M1_d N_30_X100/M1_g N_X100/6_X100/M1_s N_GND!_X26/M0_b N_18
+ L=1.8e-07 W=5e-07 AD=3.025e-13 AS=1.4e-13 PD=1.71e-06 PS=5.6e-07
mX100/M2 N_99_X100/M2_d N_133_X100/M2_g N_VDD!_X100/M2_s N_VDD!_X30/M1_b P_18
+ L=1.8e-07 W=5e-07 AD=1.4e-13 AS=2.85e-13 PD=5.6e-07 PS=1.64e-06
mX100/M3 N_VDD!_X100/M3_d N_30_X100/M3_g N_99_X100/M3_s N_VDD!_X30/M1_b P_18
+ L=1.8e-07 W=5e-07 AD=3.025e-13 AS=1.4e-13 PD=1.71e-06 PS=5.6e-07
mX101/M0 N_X101/6_X101/M0_d N_36_X101/M0_g N_GND!_X101/M0_s N_GND!_X26/M0_b N_18
+ L=1.8e-07 W=5e-07 AD=1.4e-13 AS=2.85e-13 PD=5.6e-07 PS=1.64e-06
mX101/M1 N_34_X101/M1_d N_99_X101/M1_g N_X101/6_X101/M1_s N_GND!_X26/M0_b N_18
+ L=1.8e-07 W=5e-07 AD=3.025e-13 AS=1.4e-13 PD=1.71e-06 PS=5.6e-07
mX101/M2 N_34_X101/M2_d N_36_X101/M2_g N_VDD!_X101/M2_s N_VDD!_X30/M1_b P_18
+ L=1.8e-07 W=5e-07 AD=1.4e-13 AS=2.85e-13 PD=5.6e-07 PS=1.64e-06
mX101/M3 N_VDD!_X101/M3_d N_99_X101/M3_g N_34_X101/M3_s N_VDD!_X30/M1_b P_18
+ L=1.8e-07 W=5e-07 AD=3.025e-13 AS=1.4e-13 PD=1.71e-06 PS=5.6e-07
mX102/M0 N_X102/6_X102/M0_d N_45_X102/M0_g N_GND!_X102/M0_s N_GND!_X26/M0_b N_18
+ L=1.8e-07 W=5e-07 AD=1.4e-13 AS=2.85e-13 PD=5.6e-07 PS=1.64e-06
mX102/M1 N_102_X102/M1_d N_55_X102/M1_g N_X102/6_X102/M1_s N_GND!_X26/M0_b N_18
+ L=1.8e-07 W=5e-07 AD=3.025e-13 AS=1.4e-13 PD=1.71e-06 PS=5.6e-07
mX102/M2 N_102_X102/M2_d N_45_X102/M2_g N_VDD!_X102/M2_s N_VDD!_X30/M1_b P_18
+ L=1.8e-07 W=5e-07 AD=1.4e-13 AS=2.85e-13 PD=5.6e-07 PS=1.64e-06
mX102/M3 N_VDD!_X102/M3_d N_55_X102/M3_g N_102_X102/M3_s N_VDD!_X30/M1_b P_18
+ L=1.8e-07 W=5e-07 AD=3.025e-13 AS=1.4e-13 PD=1.71e-06 PS=5.6e-07
mX103/M0 N_X103/6_X103/M0_d N_102_X103/M0_g N_GND!_X103/M0_s N_GND!_X26/M0_b
+ N_18 L=1.8e-07 W=5e-07 AD=1.4e-13 AS=2.85e-13 PD=5.6e-07 PS=1.64e-06
mX103/M1 N_105_X103/M1_d N_43_X103/M1_g N_X103/6_X103/M1_s N_GND!_X26/M0_b N_18
+ L=1.8e-07 W=5e-07 AD=3.025e-13 AS=1.4e-13 PD=1.71e-06 PS=5.6e-07
mX103/M2 N_105_X103/M2_d N_102_X103/M2_g N_VDD!_X103/M2_s N_VDD!_X30/M1_b P_18
+ L=1.8e-07 W=5e-07 AD=1.4e-13 AS=2.85e-13 PD=5.6e-07 PS=1.64e-06
mX103/M3 N_VDD!_X103/M3_d N_43_X103/M3_g N_105_X103/M3_s N_VDD!_X30/M1_b P_18
+ L=1.8e-07 W=5e-07 AD=3.025e-13 AS=1.4e-13 PD=1.71e-06 PS=5.6e-07
mX104/M0 N_X104/6_X104/M0_d N_B[3]_X104/M0_g N_GND!_X104/M0_s N_GND!_X26/M0_b
+ N_18 L=1.8e-07 W=5e-07 AD=1.4e-13 AS=2.85e-13 PD=5.6e-07 PS=1.64e-06
mX104/M1 N_103_X104/M1_d N_51_X104/M1_g N_X104/6_X104/M1_s N_GND!_X26/M0_b N_18
+ L=1.8e-07 W=5e-07 AD=3.025e-13 AS=1.4e-13 PD=1.71e-06 PS=5.6e-07
mX104/M2 N_103_X104/M2_d N_B[3]_X104/M2_g N_VDD!_X104/M2_s N_VDD!_X28/M1_b P_18
+ L=1.8e-07 W=5e-07 AD=1.4e-13 AS=2.85e-13 PD=5.6e-07 PS=1.64e-06
mX104/M3 N_VDD!_X104/M3_d N_51_X104/M3_g N_103_X104/M3_s N_VDD!_X28/M1_b P_18
+ L=1.8e-07 W=5e-07 AD=3.025e-13 AS=1.4e-13 PD=1.71e-06 PS=5.6e-07
mX105/M0 N_X105/6_X105/M0_d N_42_X105/M0_g N_GND!_X105/M0_s N_GND!_X26/M0_b N_18
+ L=1.8e-07 W=5e-07 AD=1.4e-13 AS=2.85e-13 PD=5.6e-07 PS=1.64e-06
mX105/M1 N_39_X105/M1_d N_48_X105/M1_g N_X105/6_X105/M1_s N_GND!_X26/M0_b N_18
+ L=1.8e-07 W=5e-07 AD=3.025e-13 AS=1.4e-13 PD=1.71e-06 PS=5.6e-07
mX105/M2 N_39_X105/M2_d N_42_X105/M2_g N_VDD!_X105/M2_s N_VDD!_X33/M1_b P_18
+ L=1.8e-07 W=5e-07 AD=1.4e-13 AS=2.85e-13 PD=5.6e-07 PS=1.64e-06
mX105/M3 N_VDD!_X105/M3_d N_48_X105/M3_g N_39_X105/M3_s N_VDD!_X33/M1_b P_18
+ L=1.8e-07 W=5e-07 AD=3.025e-13 AS=1.4e-13 PD=1.71e-06 PS=5.6e-07
mX106/M0 N_X106/6_X106/M0_d N_137_X106/M0_g N_GND!_X106/M0_s N_GND!_X26/M0_b
+ N_18 L=1.8e-07 W=5e-07 AD=1.4e-13 AS=2.85e-13 PD=5.6e-07 PS=1.64e-06
mX106/M1 N_43_X106/M1_d N_46_X106/M1_g N_X106/6_X106/M1_s N_GND!_X26/M0_b N_18
+ L=1.8e-07 W=5e-07 AD=3.025e-13 AS=1.4e-13 PD=1.71e-06 PS=5.6e-07
mX106/M2 N_43_X106/M2_d N_137_X106/M2_g N_VDD!_X106/M2_s N_VDD!_X30/M1_b P_18
+ L=1.8e-07 W=5e-07 AD=1.4e-13 AS=2.85e-13 PD=5.6e-07 PS=1.64e-06
mX106/M3 N_VDD!_X106/M3_d N_46_X106/M3_g N_43_X106/M3_s N_VDD!_X30/M1_b P_18
+ L=1.8e-07 W=5e-07 AD=3.025e-13 AS=1.4e-13 PD=1.71e-06 PS=5.6e-07
mX107/M0 N_X107/6_X107/M0_d N_109_X107/M0_g N_GND!_X107/M0_s N_GND!_X26/M0_b
+ N_18 L=1.8e-07 W=5e-07 AD=1.4e-13 AS=2.85e-13 PD=5.6e-07 PS=1.64e-06
mX107/M1 N_55_X107/M1_d N_107_X107/M1_g N_X107/6_X107/M1_s N_GND!_X26/M0_b N_18
+ L=1.8e-07 W=5e-07 AD=3.025e-13 AS=1.4e-13 PD=1.71e-06 PS=5.6e-07
mX107/M2 N_55_X107/M2_d N_109_X107/M2_g N_VDD!_X107/M2_s N_VDD!_X30/M1_b P_18
+ L=1.8e-07 W=5e-07 AD=1.4e-13 AS=2.85e-13 PD=5.6e-07 PS=1.64e-06
mX107/M3 N_VDD!_X107/M3_d N_107_X107/M3_g N_55_X107/M3_s N_VDD!_X30/M1_b P_18
+ L=1.8e-07 W=5e-07 AD=3.025e-13 AS=1.4e-13 PD=1.71e-06 PS=5.6e-07
mX108/M0 N_X108/6_X108/M0_d N_64_X108/M0_g N_GND!_X108/M0_s N_GND!_X26/M0_b N_18
+ L=1.8e-07 W=5e-07 AD=1.4e-13 AS=2.85e-13 PD=5.6e-07 PS=1.64e-06
mX108/M1 N_51_X108/M1_d N_112_X108/M1_g N_X108/6_X108/M1_s N_GND!_X26/M0_b N_18
+ L=1.8e-07 W=5e-07 AD=3.025e-13 AS=1.4e-13 PD=1.71e-06 PS=5.6e-07
mX108/M2 N_51_X108/M2_d N_64_X108/M2_g N_VDD!_X108/M2_s N_VDD!_X28/M1_b P_18
+ L=1.8e-07 W=5e-07 AD=1.4e-13 AS=2.85e-13 PD=5.6e-07 PS=1.64e-06
mX108/M3 N_VDD!_X108/M3_d N_112_X108/M3_g N_51_X108/M3_s N_VDD!_X28/M1_b P_18
+ L=1.8e-07 W=5e-07 AD=3.025e-13 AS=1.4e-13 PD=1.71e-06 PS=5.6e-07
mX109/M0 N_X109/6_X109/M0_d N_44_X109/M0_g N_GND!_X109/M0_s N_GND!_X26/M0_b N_18
+ L=1.8e-07 W=5e-07 AD=1.4e-13 AS=2.85e-13 PD=5.6e-07 PS=1.64e-06
mX109/M1 N_68_X109/M1_d N_50_X109/M1_g N_X109/6_X109/M1_s N_GND!_X26/M0_b N_18
+ L=1.8e-07 W=5e-07 AD=3.025e-13 AS=1.4e-13 PD=1.71e-06 PS=5.6e-07
mX109/M2 N_68_X109/M2_d N_44_X109/M2_g N_VDD!_X109/M2_s N_VDD!_X27/M1_b P_18
+ L=1.8e-07 W=5e-07 AD=1.4e-13 AS=2.85e-13 PD=5.6e-07 PS=1.64e-06
mX109/M3 N_VDD!_X109/M3_d N_50_X109/M3_g N_68_X109/M3_s N_VDD!_X27/M1_b P_18
+ L=1.8e-07 W=5e-07 AD=3.025e-13 AS=1.4e-13 PD=1.71e-06 PS=5.6e-07
mX110/M0 N_X110/6_X110/M0_d N_54_X110/M0_g N_GND!_X110/M0_s N_GND!_X26/M0_b N_18
+ L=1.8e-07 W=5e-07 AD=1.4e-13 AS=2.85e-13 PD=5.6e-07 PS=1.64e-06
mX110/M1 N_52_X110/M1_d N_113_X110/M1_g N_X110/6_X110/M1_s N_GND!_X26/M0_b N_18
+ L=1.8e-07 W=5e-07 AD=3.025e-13 AS=1.4e-13 PD=1.71e-06 PS=5.6e-07
mX110/M2 N_52_X110/M2_d N_54_X110/M2_g N_VDD!_X110/M2_s N_VDD!_X26/M1_b P_18
+ L=1.8e-07 W=5e-07 AD=1.4e-13 AS=2.85e-13 PD=5.6e-07 PS=1.64e-06
mX110/M3 N_VDD!_X110/M3_d N_113_X110/M3_g N_52_X110/M3_s N_VDD!_X26/M1_b P_18
+ L=1.8e-07 W=5e-07 AD=3.025e-13 AS=1.4e-13 PD=1.71e-06 PS=5.6e-07
mX111/M0 N_X111/6_X111/M0_d N_49_X111/M0_g N_GND!_X111/M0_s N_GND!_X26/M0_b N_18
+ L=1.8e-07 W=5e-07 AD=1.4e-13 AS=2.85e-13 PD=5.6e-07 PS=1.64e-06
mX111/M1 N_63_X111/M1_d N_53_X111/M1_g N_X111/6_X111/M1_s N_GND!_X26/M0_b N_18
+ L=1.8e-07 W=5e-07 AD=3.025e-13 AS=1.4e-13 PD=1.71e-06 PS=5.6e-07
mX111/M2 N_63_X111/M2_d N_49_X111/M2_g N_VDD!_X111/M2_s N_VDD!_X26/M1_b P_18
+ L=1.8e-07 W=5e-07 AD=1.4e-13 AS=2.85e-13 PD=5.6e-07 PS=1.64e-06
mX111/M3 N_VDD!_X111/M3_d N_53_X111/M3_g N_63_X111/M3_s N_VDD!_X26/M1_b P_18
+ L=1.8e-07 W=5e-07 AD=3.025e-13 AS=1.4e-13 PD=1.71e-06 PS=5.6e-07
mX112/M0 N_X112/6_X112/M0_d N_115_X112/M0_g N_GND!_X112/M0_s N_GND!_X26/M0_b
+ N_18 L=1.8e-07 W=5e-07 AD=1.4e-13 AS=2.85e-13 PD=5.6e-07 PS=1.64e-06
mX112/M1 N_110_X112/M1_d N_57_X112/M1_g N_X112/6_X112/M1_s N_GND!_X26/M0_b N_18
+ L=1.8e-07 W=5e-07 AD=3.025e-13 AS=1.4e-13 PD=1.71e-06 PS=5.6e-07
mX112/M2 N_110_X112/M2_d N_115_X112/M2_g N_VDD!_X112/M2_s N_VDD!_X33/M1_b P_18
+ L=1.8e-07 W=5e-07 AD=1.4e-13 AS=2.85e-13 PD=5.6e-07 PS=1.64e-06
mX112/M3 N_VDD!_X112/M3_d N_57_X112/M3_g N_110_X112/M3_s N_VDD!_X33/M1_b P_18
+ L=1.8e-07 W=5e-07 AD=3.025e-13 AS=1.4e-13 PD=1.71e-06 PS=5.6e-07
mX113/M0 N_X113/6_X113/M0_d N_48_X113/M0_g N_GND!_X113/M0_s N_GND!_X26/M0_b N_18
+ L=1.8e-07 W=5e-07 AD=1.4e-13 AS=2.85e-13 PD=5.6e-07 PS=1.64e-06
mX113/M1 N_61_X113/M1_d N_114_X113/M1_g N_X113/6_X113/M1_s N_GND!_X26/M0_b N_18
+ L=1.8e-07 W=5e-07 AD=3.025e-13 AS=1.4e-13 PD=1.71e-06 PS=5.6e-07
mX113/M2 N_61_X113/M2_d N_48_X113/M2_g N_VDD!_X113/M2_s N_VDD!_X33/M1_b P_18
+ L=1.8e-07 W=5e-07 AD=1.4e-13 AS=2.85e-13 PD=5.6e-07 PS=1.64e-06
mX113/M3 N_VDD!_X113/M3_d N_114_X113/M3_g N_61_X113/M3_s N_VDD!_X33/M1_b P_18
+ L=1.8e-07 W=5e-07 AD=3.025e-13 AS=1.4e-13 PD=1.71e-06 PS=5.6e-07
mX114/M0 N_X114/6_X114/M0_d N_B[1]_X114/M0_g N_GND!_X114/M0_s N_GND!_X26/M0_b
+ N_18 L=1.8e-07 W=5e-07 AD=1.4e-13 AS=2.85e-13 PD=5.6e-07 PS=1.64e-06
mX114/M1 N_117_X114/M1_d N_58_X114/M1_g N_X114/6_X114/M1_s N_GND!_X26/M0_b N_18
+ L=1.8e-07 W=5e-07 AD=3.025e-13 AS=1.4e-13 PD=1.71e-06 PS=5.6e-07
mX114/M2 N_117_X114/M2_d N_B[1]_X114/M2_g N_VDD!_X114/M2_s N_VDD!_X30/M1_b P_18
+ L=1.8e-07 W=5e-07 AD=1.4e-13 AS=2.85e-13 PD=5.6e-07 PS=1.64e-06
mX114/M3 N_VDD!_X114/M3_d N_58_X114/M3_g N_117_X114/M3_s N_VDD!_X30/M1_b P_18
+ L=1.8e-07 W=5e-07 AD=3.025e-13 AS=1.4e-13 PD=1.71e-06 PS=5.6e-07
mX115/M0 N_X115/6_X115/M0_d N_68_X115/M0_g N_GND!_X115/M0_s N_GND!_X26/M0_b N_18
+ L=1.8e-07 W=5e-07 AD=1.4e-13 AS=2.85e-13 PD=5.6e-07 PS=1.64e-06
mX115/M1 N_60_X115/M1_d N_108_X115/M1_g N_X115/6_X115/M1_s N_GND!_X26/M0_b N_18
+ L=1.8e-07 W=5e-07 AD=3.025e-13 AS=1.4e-13 PD=1.71e-06 PS=5.6e-07
mX115/M2 N_60_X115/M2_d N_68_X115/M2_g N_VDD!_X115/M2_s N_VDD!_X28/M1_b P_18
+ L=1.8e-07 W=5e-07 AD=1.4e-13 AS=2.85e-13 PD=5.6e-07 PS=1.64e-06
mX115/M3 N_VDD!_X115/M3_d N_108_X115/M3_g N_60_X115/M3_s N_VDD!_X28/M1_b P_18
+ L=1.8e-07 W=5e-07 AD=3.025e-13 AS=1.4e-13 PD=1.71e-06 PS=5.6e-07
mX116/M0 N_X116/6_X116/M0_d N_A[2]_X116/M0_g N_GND!_X116/M0_s N_GND!_X26/M0_b
+ N_18 L=1.8e-07 W=5e-07 AD=1.4e-13 AS=2.85e-13 PD=5.6e-07 PS=1.64e-06
mX116/M1 N_115_X116/M1_d N_119_X116/M1_g N_X116/6_X116/M1_s N_GND!_X26/M0_b N_18
+ L=1.8e-07 W=5e-07 AD=3.025e-13 AS=1.4e-13 PD=1.71e-06 PS=5.6e-07
mX116/M2 N_115_X116/M2_d N_A[2]_X116/M2_g N_VDD!_X116/M2_s N_VDD!_X33/M1_b P_18
+ L=1.8e-07 W=5e-07 AD=1.4e-13 AS=2.85e-13 PD=5.6e-07 PS=1.64e-06
mX116/M3 N_VDD!_X116/M3_d N_119_X116/M3_g N_115_X116/M3_s N_VDD!_X33/M1_b P_18
+ L=1.8e-07 W=5e-07 AD=3.025e-13 AS=1.4e-13 PD=1.71e-06 PS=5.6e-07
mX117/M0 N_X117/6_X117/M0_d N_124_X117/M0_g N_GND!_X117/M0_s N_GND!_X26/M0_b
+ N_18 L=1.8e-07 W=5e-07 AD=1.4e-13 AS=2.85e-13 PD=5.6e-07 PS=1.64e-06
mX117/M1 N_108_X117/M1_d N_116_X117/M1_g N_X117/6_X117/M1_s N_GND!_X26/M0_b N_18
+ L=1.8e-07 W=5e-07 AD=3.025e-13 AS=1.4e-13 PD=1.71e-06 PS=5.6e-07
mX117/M2 N_108_X117/M2_d N_124_X117/M2_g N_VDD!_X117/M2_s N_VDD!_X28/M1_b P_18
+ L=1.8e-07 W=5e-07 AD=1.4e-13 AS=2.85e-13 PD=5.6e-07 PS=1.64e-06
mX117/M3 N_VDD!_X117/M3_d N_116_X117/M3_g N_108_X117/M3_s N_VDD!_X28/M1_b P_18
+ L=1.8e-07 W=5e-07 AD=3.025e-13 AS=1.4e-13 PD=1.71e-06 PS=5.6e-07
mX118/M0 N_X118/6_X118/M0_d N_72_X118/M0_g N_GND!_X118/M0_s N_GND!_X26/M0_b N_18
+ L=1.8e-07 W=5e-07 AD=1.4e-13 AS=2.85e-13 PD=5.6e-07 PS=1.64e-06
mX118/M1 N_45_X118/M1_d N_117_X118/M1_g N_X118/6_X118/M1_s N_GND!_X26/M0_b N_18
+ L=1.8e-07 W=5e-07 AD=3.025e-13 AS=1.4e-13 PD=1.71e-06 PS=5.6e-07
mX118/M2 N_45_X118/M2_d N_72_X118/M2_g N_VDD!_X118/M2_s N_VDD!_X30/M1_b P_18
+ L=1.8e-07 W=5e-07 AD=1.4e-13 AS=2.85e-13 PD=5.6e-07 PS=1.64e-06
mX118/M3 N_VDD!_X118/M3_d N_117_X118/M3_g N_45_X118/M3_s N_VDD!_X30/M1_b P_18
+ L=1.8e-07 W=5e-07 AD=3.025e-13 AS=1.4e-13 PD=1.71e-06 PS=5.6e-07
mX119/M0 N_X119/6_X119/M0_d N_60_X119/M0_g N_GND!_X119/M0_s N_GND!_X26/M0_b N_18
+ L=1.8e-07 W=5e-07 AD=1.4e-13 AS=2.85e-13 PD=5.6e-07 PS=1.64e-06
mX119/M1 N_121_X119/M1_d N_120_X119/M1_g N_X119/6_X119/M1_s N_GND!_X26/M0_b N_18
+ L=1.8e-07 W=5e-07 AD=3.025e-13 AS=1.4e-13 PD=1.71e-06 PS=5.6e-07
mX119/M2 N_121_X119/M2_d N_60_X119/M2_g N_VDD!_X119/M2_s N_VDD!_X27/M1_b P_18
+ L=1.8e-07 W=5e-07 AD=1.4e-13 AS=2.85e-13 PD=5.6e-07 PS=1.64e-06
mX119/M3 N_VDD!_X119/M3_d N_120_X119/M3_g N_121_X119/M3_s N_VDD!_X27/M1_b P_18
+ L=1.8e-07 W=5e-07 AD=3.025e-13 AS=1.4e-13 PD=1.71e-06 PS=5.6e-07
mX120/M0 N_X120/6_X120/M0_d N_138_X120/M0_g N_GND!_X120/M0_s N_GND!_X26/M0_b
+ N_18 L=1.8e-07 W=5e-07 AD=1.4e-13 AS=2.85e-13 PD=5.6e-07 PS=1.64e-06
mX120/M1 N_120_X120/M1_d N_64_X120/M1_g N_X120/6_X120/M1_s N_GND!_X26/M0_b N_18
+ L=1.8e-07 W=5e-07 AD=3.025e-13 AS=1.4e-13 PD=1.71e-06 PS=5.6e-07
mX120/M2 N_120_X120/M2_d N_138_X120/M2_g N_VDD!_X120/M2_s N_VDD!_X28/M1_b P_18
+ L=1.8e-07 W=5e-07 AD=1.4e-13 AS=2.85e-13 PD=5.6e-07 PS=1.64e-06
mX120/M3 N_VDD!_X120/M3_d N_64_X120/M3_g N_120_X120/M3_s N_VDD!_X28/M1_b P_18
+ L=1.8e-07 W=5e-07 AD=3.025e-13 AS=1.4e-13 PD=1.71e-06 PS=5.6e-07
mX121/M0 N_X121/6_X121/M0_d N_A[2]_X121/M0_g N_GND!_X121/M0_s N_GND!_X26/M0_b
+ N_18 L=1.8e-07 W=5e-07 AD=1.4e-13 AS=2.85e-13 PD=5.6e-07 PS=1.64e-06
mX121/M1 N_124_X121/M1_d N_69_X121/M1_g N_X121/6_X121/M1_s N_GND!_X26/M0_b N_18
+ L=1.8e-07 W=5e-07 AD=3.025e-13 AS=1.4e-13 PD=1.71e-06 PS=5.6e-07
mX121/M2 N_124_X121/M2_d N_A[2]_X121/M2_g N_VDD!_X121/M2_s N_VDD!_X33/M1_b P_18
+ L=1.8e-07 W=5e-07 AD=1.4e-13 AS=2.85e-13 PD=5.6e-07 PS=1.64e-06
mX121/M3 N_VDD!_X121/M3_d N_69_X121/M3_g N_124_X121/M3_s N_VDD!_X33/M1_b P_18
+ L=1.8e-07 W=5e-07 AD=3.025e-13 AS=1.4e-13 PD=1.71e-06 PS=5.6e-07
mX122/M0 N_X122/6_X122/M0_d N_A[1]_X122/M0_g N_GND!_X122/M0_s N_GND!_X26/M0_b
+ N_18 L=1.8e-07 W=5e-07 AD=1.4e-13 AS=2.85e-13 PD=5.6e-07 PS=1.64e-06
mX122/M1 N_72_X122/M1_d N_125_X122/M1_g N_X122/6_X122/M1_s N_GND!_X26/M0_b N_18
+ L=1.8e-07 W=5e-07 AD=3.025e-13 AS=1.4e-13 PD=1.71e-06 PS=5.6e-07
mX122/M2 N_72_X122/M2_d N_A[1]_X122/M2_g N_VDD!_X122/M2_s N_VDD!_X30/M1_b P_18
+ L=1.8e-07 W=5e-07 AD=1.4e-13 AS=2.85e-13 PD=5.6e-07 PS=1.64e-06
mX122/M3 N_VDD!_X122/M3_d N_125_X122/M3_g N_72_X122/M3_s N_VDD!_X30/M1_b P_18
+ L=1.8e-07 W=5e-07 AD=3.025e-13 AS=1.4e-13 PD=1.71e-06 PS=5.6e-07
mX123/M0 N_X123/6_X123/M0_d N_66_X123/M0_g N_GND!_X123/M0_s N_GND!_X26/M0_b N_18
+ L=1.8e-07 W=5e-07 AD=1.4e-13 AS=2.85e-13 PD=5.6e-07 PS=1.64e-06
mX123/M1 N_SUM[0]_X123/M1_d N_123_X123/M1_g N_X123/6_X123/M1_s N_GND!_X26/M0_b
+ N_18 L=1.8e-07 W=5e-07 AD=3.025e-13 AS=1.4e-13 PD=1.71e-06 PS=5.6e-07
mX123/M2 N_SUM[0]_X123/M2_d N_66_X123/M2_g N_VDD!_X123/M2_s N_VDD!_X26/M1_b P_18
+ L=1.8e-07 W=5e-07 AD=1.4e-13 AS=2.85e-13 PD=5.6e-07 PS=1.64e-06
mX123/M3 N_VDD!_X123/M3_d N_123_X123/M3_g N_SUM[0]_X123/M3_s N_VDD!_X26/M1_b
+ P_18 L=1.8e-07 W=5e-07 AD=3.025e-13 AS=1.4e-13 PD=1.71e-06 PS=5.6e-07
mX124/X0/M0 N_X124/X0/6_X124/X0/M0_d N_A[6]_X124/X0/M0_g N_GND!_X124/X0/M0_s
+ N_GND!_X26/M0_b N_18 L=1.8e-07 W=5e-07 AD=1.4e-13 AS=2.85e-13 PD=5.6e-07
+ PS=1.64e-06
mX124/X0/M1 N_127_X124/X0/M1_d N_76_X124/X0/M1_g N_X124/X0/6_X124/X0/M1_s
+ N_GND!_X26/M0_b N_18 L=1.8e-07 W=5e-07 AD=3.025e-13 AS=1.4e-13 PD=1.71e-06
+ PS=5.6e-07
mX124/X0/M2 N_127_X124/X0/M2_d N_A[6]_X124/X0/M2_g N_VDD!_X124/X0/M2_s
+ N_VDD!_X30/M1_b P_18 L=1.8e-07 W=5e-07 AD=1.4e-13 AS=2.85e-13 PD=5.6e-07
+ PS=1.64e-06
mX124/X0/M3 N_VDD!_X124/X0/M3_d N_76_X124/X0/M3_g N_127_X124/X0/M3_s
+ N_VDD!_X30/M1_b P_18 L=1.8e-07 W=5e-07 AD=3.025e-13 AS=1.4e-13 PD=1.71e-06
+ PS=5.6e-07
mX124/X1/M0 N_X124/X1/6_X124/X1/M0_d N_127_X124/X1/M0_g N_GND!_X124/X1/M0_s
+ N_GND!_X26/M0_b N_18 L=1.8e-07 W=5e-07 AD=1.4e-13 AS=2.85e-13 PD=5.6e-07
+ PS=1.64e-06
mX124/X1/M1 N_20_X124/X1/M1_d N_14_X124/X1/M1_g N_X124/X1/6_X124/X1/M1_s
+ N_GND!_X26/M0_b N_18 L=1.8e-07 W=5e-07 AD=3.025e-13 AS=1.4e-13 PD=1.71e-06
+ PS=5.6e-07
mX124/X1/M2 N_20_X124/X1/M2_d N_127_X124/X1/M2_g N_VDD!_X124/X1/M2_s
+ N_VDD!_X30/M1_b P_18 L=1.8e-07 W=5e-07 AD=1.4e-13 AS=2.85e-13 PD=5.6e-07
+ PS=1.64e-06
mX124/X1/M3 N_VDD!_X124/X1/M3_d N_14_X124/X1/M3_g N_20_X124/X1/M3_s
+ N_VDD!_X30/M1_b P_18 L=1.8e-07 W=5e-07 AD=3.025e-13 AS=1.4e-13 PD=1.71e-06
+ PS=5.6e-07
mX125/X0/M0 N_X125/X0/6_X125/X0/M0_d N_B[5]_X125/X0/M0_g N_GND!_X125/X0/M0_s
+ N_GND!_X26/M0_b N_18 L=1.8e-07 W=5e-07 AD=1.4e-13 AS=2.85e-13 PD=5.6e-07
+ PS=1.64e-06
mX125/X0/M1 N_80_X125/X0/M1_d N_10_X125/X0/M1_g N_X125/X0/6_X125/X0/M1_s
+ N_GND!_X26/M0_b N_18 L=1.8e-07 W=5e-07 AD=3.025e-13 AS=1.4e-13 PD=1.71e-06
+ PS=5.6e-07
mX125/X0/M2 N_80_X125/X0/M2_d N_B[5]_X125/X0/M2_g N_VDD!_X125/X0/M2_s
+ N_VDD!_X33/M1_b P_18 L=1.8e-07 W=5e-07 AD=1.4e-13 AS=2.85e-13 PD=5.6e-07
+ PS=1.64e-06
mX125/X0/M3 N_VDD!_X125/X0/M3_d N_10_X125/X0/M3_g N_80_X125/X0/M3_s
+ N_VDD!_X33/M1_b P_18 L=1.8e-07 W=5e-07 AD=3.025e-13 AS=1.4e-13 PD=1.71e-06
+ PS=5.6e-07
mX125/X1/M0 N_X125/X1/6_X125/X1/M0_d N_82_X125/X1/M0_g N_GND!_X125/X1/M0_s
+ N_GND!_X26/M0_b N_18 L=1.8e-07 W=5e-07 AD=1.4e-13 AS=2.85e-13 PD=5.6e-07
+ PS=1.64e-06
mX125/X1/M1 N_81_X125/X1/M1_d N_10_X125/X1/M1_g N_X125/X1/6_X125/X1/M1_s
+ N_GND!_X26/M0_b N_18 L=1.8e-07 W=5e-07 AD=3.025e-13 AS=1.4e-13 PD=1.71e-06
+ PS=5.6e-07
mX125/X1/M2 N_81_X125/X1/M2_d N_82_X125/X1/M2_g N_VDD!_X125/X1/M2_s
+ N_VDD!_X33/M1_b P_18 L=1.8e-07 W=5e-07 AD=1.4e-13 AS=2.85e-13 PD=5.6e-07
+ PS=1.64e-06
mX125/X1/M3 N_VDD!_X125/X1/M3_d N_10_X125/X1/M3_g N_81_X125/X1/M3_s
+ N_VDD!_X33/M1_b P_18 L=1.8e-07 W=5e-07 AD=3.025e-13 AS=1.4e-13 PD=1.71e-06
+ PS=5.6e-07
mX126/X0/M0 N_X126/X0/6_X126/X0/M0_d N_83_X126/X0/M0_g N_GND!_X126/X0/M0_s
+ N_GND!_X26/M0_b N_18 L=1.8e-07 W=5e-07 AD=1.4e-13 AS=2.85e-13 PD=5.6e-07
+ PS=1.64e-06
mX126/X0/M1 N_35_X126/X0/M1_d N_93_X126/X0/M1_g N_X126/X0/6_X126/X0/M1_s
+ N_GND!_X26/M0_b N_18 L=1.8e-07 W=5e-07 AD=3.025e-13 AS=1.4e-13 PD=1.71e-06
+ PS=5.6e-07
mX126/X0/M2 N_35_X126/X0/M2_d N_83_X126/X0/M2_g N_VDD!_X126/X0/M2_s
+ N_VDD!_X26/M1_b P_18 L=1.8e-07 W=5e-07 AD=1.4e-13 AS=2.85e-13 PD=5.6e-07
+ PS=1.64e-06
mX126/X0/M3 N_VDD!_X126/X0/M3_d N_93_X126/X0/M3_g N_35_X126/X0/M3_s
+ N_VDD!_X26/M1_b P_18 L=1.8e-07 W=5e-07 AD=3.025e-13 AS=1.4e-13 PD=1.71e-06
+ PS=5.6e-07
mX126/X1/M0 N_X126/X1/6_X126/X1/M0_d N_A[7]_X126/X1/M0_g N_GND!_X126/X1/M0_s
+ N_GND!_X26/M0_b N_18 L=1.8e-07 W=5e-07 AD=1.4e-13 AS=2.85e-13 PD=5.6e-07
+ PS=1.64e-06
mX126/X1/M1 N_33_X126/X1/M1_d N_25_X126/X1/M1_g N_X126/X1/6_X126/X1/M1_s
+ N_GND!_X26/M0_b N_18 L=1.8e-07 W=5e-07 AD=3.025e-13 AS=1.4e-13 PD=1.71e-06
+ PS=5.6e-07
mX126/X1/M2 N_33_X126/X1/M2_d N_A[7]_X126/X1/M2_g N_VDD!_X126/X1/M2_s
+ N_VDD!_X26/M1_b P_18 L=1.8e-07 W=5e-07 AD=1.4e-13 AS=2.85e-13 PD=5.6e-07
+ PS=1.64e-06
mX126/X1/M3 N_VDD!_X126/X1/M3_d N_25_X126/X1/M3_g N_33_X126/X1/M3_s
+ N_VDD!_X26/M1_b P_18 L=1.8e-07 W=5e-07 AD=3.025e-13 AS=1.4e-13 PD=1.71e-06
+ PS=5.6e-07
mX127/X0/M0 N_X127/X0/6_X127/X0/M0_d N_CIN_X127/X0/M0_g N_GND!_X127/X0/M0_s
+ N_GND!_X26/M0_b N_18 L=1.8e-07 W=5e-07 AD=1.4e-13 AS=2.85e-13 PD=5.6e-07
+ PS=1.64e-06
mX127/X0/M1 N_107_X127/X0/M1_d N_52_X127/X0/M1_g N_X127/X0/6_X127/X0/M1_s
+ N_GND!_X26/M0_b N_18 L=1.8e-07 W=5e-07 AD=3.025e-13 AS=1.4e-13 PD=1.71e-06
+ PS=5.6e-07
mX127/X0/M2 N_107_X127/X0/M2_d N_CIN_X127/X0/M2_g N_VDD!_X127/X0/M2_s
+ N_VDD!_X26/M1_b P_18 L=1.8e-07 W=5e-07 AD=1.4e-13 AS=2.85e-13 PD=5.6e-07
+ PS=1.64e-06
mX127/X0/M3 N_VDD!_X127/X0/M3_d N_52_X127/X0/M3_g N_107_X127/X0/M3_s
+ N_VDD!_X26/M1_b P_18 L=1.8e-07 W=5e-07 AD=3.025e-13 AS=1.4e-13 PD=1.71e-06
+ PS=5.6e-07
mX127/X1/M0 N_X127/X1/6_X127/X1/M0_d N_B[0]_X127/X1/M0_g N_GND!_X127/X1/M0_s
+ N_GND!_X26/M0_b N_18 L=1.8e-07 W=5e-07 AD=1.4e-13 AS=2.85e-13 PD=5.6e-07
+ PS=1.64e-06
mX127/X1/M1 N_109_X127/X1/M1_d N_A[0]_X127/X1/M1_g N_X127/X1/6_X127/X1/M1_s
+ N_GND!_X26/M0_b N_18 L=1.8e-07 W=5e-07 AD=3.025e-13 AS=1.4e-13 PD=1.71e-06
+ PS=5.6e-07
mX127/X1/M2 N_109_X127/X1/M2_d N_B[0]_X127/X1/M2_g N_VDD!_X127/X1/M2_s
+ N_VDD!_X26/M1_b P_18 L=1.8e-07 W=5e-07 AD=1.4e-13 AS=2.85e-13 PD=5.6e-07
+ PS=1.64e-06
mX127/X1/M3 N_VDD!_X127/X1/M3_d N_A[0]_X127/X1/M3_g N_109_X127/X1/M3_s
+ N_VDD!_X26/M1_b P_18 L=1.8e-07 W=5e-07 AD=3.025e-13 AS=1.4e-13 PD=1.71e-06
+ PS=5.6e-07
mX128/X0/M0 N_X128/X0/6_X128/X0/M0_d N_A[3]_X128/X0/M0_g N_GND!_X128/X0/M0_s
+ N_GND!_X26/M0_b N_18 L=1.8e-07 W=5e-07 AD=1.4e-13 AS=2.85e-13 PD=5.6e-07
+ PS=1.64e-06
mX128/X0/M1 N_44_X128/X0/M1_d N_106_X128/X0/M1_g N_X128/X0/6_X128/X0/M1_s
+ N_GND!_X26/M0_b N_18 L=1.8e-07 W=5e-07 AD=3.025e-13 AS=1.4e-13 PD=1.71e-06
+ PS=5.6e-07
mX128/X0/M2 N_44_X128/X0/M2_d N_A[3]_X128/X0/M2_g N_VDD!_X128/X0/M2_s
+ N_VDD!_X27/M1_b P_18 L=1.8e-07 W=5e-07 AD=1.4e-13 AS=2.85e-13 PD=5.6e-07
+ PS=1.64e-06
mX128/X0/M3 N_VDD!_X128/X0/M3_d N_106_X128/X0/M3_g N_44_X128/X0/M3_s
+ N_VDD!_X27/M1_b P_18 L=1.8e-07 W=5e-07 AD=3.025e-13 AS=1.4e-13 PD=1.71e-06
+ PS=5.6e-07
mX128/X1/M0 N_X128/X1/6_X128/X1/M0_d N_B[3]_X128/X1/M0_g N_GND!_X128/X1/M0_s
+ N_GND!_X26/M0_b N_18 L=1.8e-07 W=5e-07 AD=1.4e-13 AS=2.85e-13 PD=5.6e-07
+ PS=1.64e-06
mX128/X1/M1 N_50_X128/X1/M1_d N_112_X128/X1/M1_g N_X128/X1/6_X128/X1/M1_s
+ N_GND!_X26/M0_b N_18 L=1.8e-07 W=5e-07 AD=3.025e-13 AS=1.4e-13 PD=1.71e-06
+ PS=5.6e-07
mX128/X1/M2 N_50_X128/X1/M2_d N_B[3]_X128/X1/M2_g N_VDD!_X128/X1/M2_s
+ N_VDD!_X27/M1_b P_18 L=1.8e-07 W=5e-07 AD=1.4e-13 AS=2.85e-13 PD=5.6e-07
+ PS=1.64e-06
mX128/X1/M3 N_VDD!_X128/X1/M3_d N_112_X128/X1/M3_g N_50_X128/X1/M3_s
+ N_VDD!_X27/M1_b P_18 L=1.8e-07 W=5e-07 AD=3.025e-13 AS=1.4e-13 PD=1.71e-06
+ PS=5.6e-07
mX129/X0/M0 N_X129/X0/6_X129/X0/M0_d N_B[0]_X129/X0/M0_g N_GND!_X129/X0/M0_s
+ N_GND!_X26/M0_b N_18 L=1.8e-07 W=5e-07 AD=1.4e-13 AS=2.85e-13 PD=5.6e-07
+ PS=1.64e-06
mX129/X0/M1 N_49_X129/X0/M1_d N_41_X129/X0/M1_g N_X129/X0/6_X129/X0/M1_s
+ N_GND!_X26/M0_b N_18 L=1.8e-07 W=5e-07 AD=3.025e-13 AS=1.4e-13 PD=1.71e-06
+ PS=5.6e-07
mX129/X0/M2 N_49_X129/X0/M2_d N_B[0]_X129/X0/M2_g N_VDD!_X129/X0/M2_s
+ N_VDD!_X26/M1_b P_18 L=1.8e-07 W=5e-07 AD=1.4e-13 AS=2.85e-13 PD=5.6e-07
+ PS=1.64e-06
mX129/X0/M3 N_VDD!_X129/X0/M3_d N_41_X129/X0/M3_g N_49_X129/X0/M3_s
+ N_VDD!_X26/M1_b P_18 L=1.8e-07 W=5e-07 AD=3.025e-13 AS=1.4e-13 PD=1.71e-06
+ PS=5.6e-07
mX129/X1/M0 N_X129/X1/6_X129/X1/M0_d N_CIN_X129/X1/M0_g N_GND!_X129/X1/M0_s
+ N_GND!_X26/M0_b N_18 L=1.8e-07 W=5e-07 AD=1.4e-13 AS=2.85e-13 PD=5.6e-07
+ PS=1.64e-06
mX129/X1/M1 N_53_X129/X1/M1_d N_54_X129/X1/M1_g N_X129/X1/6_X129/X1/M1_s
+ N_GND!_X26/M0_b N_18 L=1.8e-07 W=5e-07 AD=3.025e-13 AS=1.4e-13 PD=1.71e-06
+ PS=5.6e-07
mX129/X1/M2 N_53_X129/X1/M2_d N_CIN_X129/X1/M2_g N_VDD!_X129/X1/M2_s
+ N_VDD!_X26/M1_b P_18 L=1.8e-07 W=5e-07 AD=1.4e-13 AS=2.85e-13 PD=5.6e-07
+ PS=1.64e-06
mX129/X1/M3 N_VDD!_X129/X1/M3_d N_54_X129/X1/M3_g N_53_X129/X1/M3_s
+ N_VDD!_X26/M1_b P_18 L=1.8e-07 W=5e-07 AD=3.025e-13 AS=1.4e-13 PD=1.71e-06
+ PS=5.6e-07
mX130/X0/M0 N_X130/X0/6_X130/X0/M0_d N_46_X130/X0/M0_g N_GND!_X130/X0/M0_s
+ N_GND!_X26/M0_b N_18 L=1.8e-07 W=5e-07 AD=1.4e-13 AS=2.85e-13 PD=5.6e-07
+ PS=1.64e-06
mX130/X0/M1 N_59_X130/X0/M1_d N_58_X130/X0/M1_g N_X130/X0/6_X130/X0/M1_s
+ N_GND!_X26/M0_b N_18 L=1.8e-07 W=5e-07 AD=3.025e-13 AS=1.4e-13 PD=1.71e-06
+ PS=5.6e-07
mX130/X0/M2 N_59_X130/X0/M2_d N_46_X130/X0/M2_g N_VDD!_X130/X0/M2_s
+ N_VDD!_X30/M1_b P_18 L=1.8e-07 W=5e-07 AD=1.4e-13 AS=2.85e-13 PD=5.6e-07
+ PS=1.64e-06
mX130/X0/M3 N_VDD!_X130/X0/M3_d N_58_X130/X0/M3_g N_59_X130/X0/M3_s
+ N_VDD!_X30/M1_b P_18 L=1.8e-07 W=5e-07 AD=3.025e-13 AS=1.4e-13 PD=1.71e-06
+ PS=5.6e-07
mX130/X1/M0 N_X130/X1/6_X130/X1/M0_d N_A[1]_X130/X1/M0_g N_GND!_X130/X1/M0_s
+ N_GND!_X26/M0_b N_18 L=1.8e-07 W=5e-07 AD=1.4e-13 AS=2.85e-13 PD=5.6e-07
+ PS=1.64e-06
mX130/X1/M1 N_62_X130/X1/M1_d N_55_X130/X1/M1_g N_X130/X1/6_X130/X1/M1_s
+ N_GND!_X26/M0_b N_18 L=1.8e-07 W=5e-07 AD=3.025e-13 AS=1.4e-13 PD=1.71e-06
+ PS=5.6e-07
mX130/X1/M2 N_62_X130/X1/M2_d N_A[1]_X130/X1/M2_g N_VDD!_X130/X1/M2_s
+ N_VDD!_X30/M1_b P_18 L=1.8e-07 W=5e-07 AD=1.4e-13 AS=2.85e-13 PD=5.6e-07
+ PS=1.64e-06
mX130/X1/M3 N_VDD!_X130/X1/M3_d N_55_X130/X1/M3_g N_62_X130/X1/M3_s
+ N_VDD!_X30/M1_b P_18 L=1.8e-07 W=5e-07 AD=3.025e-13 AS=1.4e-13 PD=1.71e-06
+ PS=5.6e-07
mX131/X0/M0 N_X131/X0/6_X131/X0/M0_d N_B[1]_X131/X0/M0_g N_GND!_X131/X0/M0_s
+ N_GND!_X26/M0_b N_18 L=1.8e-07 W=5e-07 AD=1.4e-13 AS=2.85e-13 PD=5.6e-07
+ PS=1.64e-06
mX131/X0/M1 N_65_X131/X0/M1_d N_59_X131/X0/M1_g N_X131/X0/6_X131/X0/M1_s
+ N_GND!_X26/M0_b N_18 L=1.8e-07 W=5e-07 AD=3.025e-13 AS=1.4e-13 PD=1.71e-06
+ PS=5.6e-07
mX131/X0/M2 N_65_X131/X0/M2_d N_B[1]_X131/X0/M2_g N_VDD!_X131/X0/M2_s
+ N_VDD!_X30/M1_b P_18 L=1.8e-07 W=5e-07 AD=1.4e-13 AS=2.85e-13 PD=5.6e-07
+ PS=1.64e-06
mX131/X0/M3 N_VDD!_X131/X0/M3_d N_59_X131/X0/M3_g N_65_X131/X0/M3_s
+ N_VDD!_X30/M1_b P_18 L=1.8e-07 W=5e-07 AD=3.025e-13 AS=1.4e-13 PD=1.71e-06
+ PS=5.6e-07
mX131/X1/M0 N_X131/X1/6_X131/X1/M0_d N_62_X131/X1/M0_g N_GND!_X131/X1/M0_s
+ N_GND!_X26/M0_b N_18 L=1.8e-07 W=5e-07 AD=1.4e-13 AS=2.85e-13 PD=5.6e-07
+ PS=1.64e-06
mX131/X1/M1 N_69_X131/X1/M1_d N_65_X131/X1/M1_g N_X131/X1/6_X131/X1/M1_s
+ N_GND!_X26/M0_b N_18 L=1.8e-07 W=5e-07 AD=3.025e-13 AS=1.4e-13 PD=1.71e-06
+ PS=5.6e-07
mX131/X1/M2 N_69_X131/X1/M2_d N_62_X131/X1/M2_g N_VDD!_X131/X1/M2_s
+ N_VDD!_X30/M1_b P_18 L=1.8e-07 W=5e-07 AD=1.4e-13 AS=2.85e-13 PD=5.6e-07
+ PS=1.64e-06
mX131/X1/M3 N_VDD!_X131/X1/M3_d N_65_X131/X1/M3_g N_69_X131/X1/M3_s
+ N_VDD!_X30/M1_b P_18 L=1.8e-07 W=5e-07 AD=3.025e-13 AS=1.4e-13 PD=1.71e-06
+ PS=5.6e-07
mX132/X0/M0 N_X132/X0/6_X132/X0/M0_d N_63_X132/X0/M0_g N_GND!_X132/X0/M0_s
+ N_GND!_X26/M0_b N_18 L=1.8e-07 W=5e-07 AD=1.4e-13 AS=2.85e-13 PD=5.6e-07
+ PS=1.64e-06
mX132/X0/M1 N_66_X132/X0/M1_d N_113_X132/X0/M1_g N_X132/X0/6_X132/X0/M1_s
+ N_GND!_X26/M0_b N_18 L=1.8e-07 W=5e-07 AD=3.025e-13 AS=1.4e-13 PD=1.71e-06
+ PS=5.6e-07
mX132/X0/M2 N_66_X132/X0/M2_d N_63_X132/X0/M2_g N_VDD!_X132/X0/M2_s
+ N_VDD!_X26/M1_b P_18 L=1.8e-07 W=5e-07 AD=1.4e-13 AS=2.85e-13 PD=5.6e-07
+ PS=1.64e-06
mX132/X0/M3 N_VDD!_X132/X0/M3_d N_113_X132/X0/M3_g N_66_X132/X0/M3_s
+ N_VDD!_X26/M1_b P_18 L=1.8e-07 W=5e-07 AD=3.025e-13 AS=1.4e-13 PD=1.71e-06
+ PS=5.6e-07
mX132/X1/M0 N_X132/X1/6_X132/X1/M0_d N_118_X132/X1/M0_g N_GND!_X132/X1/M0_s
+ N_GND!_X26/M0_b N_18 L=1.8e-07 W=5e-07 AD=1.4e-13 AS=2.85e-13 PD=5.6e-07
+ PS=1.64e-06
mX132/X1/M1 N_123_X132/X1/M1_d N_A[0]_X132/X1/M1_g N_X132/X1/6_X132/X1/M1_s
+ N_GND!_X26/M0_b N_18 L=1.8e-07 W=5e-07 AD=3.025e-13 AS=1.4e-13 PD=1.71e-06
+ PS=5.6e-07
mX132/X1/M2 N_123_X132/X1/M2_d N_118_X132/X1/M2_g N_VDD!_X132/X1/M2_s
+ N_VDD!_X26/M1_b P_18 L=1.8e-07 W=5e-07 AD=1.4e-13 AS=2.85e-13 PD=5.6e-07
+ PS=1.64e-06
mX132/X1/M3 N_VDD!_X132/X1/M3_d N_A[0]_X132/X1/M3_g N_123_X132/X1/M3_s
+ N_VDD!_X26/M1_b P_18 L=1.8e-07 W=5e-07 AD=3.025e-13 AS=1.4e-13 PD=1.71e-06
+ PS=5.6e-07
mX133/X0/M0 N_X133/X0/6_X133/X0/M0_d N_131_X133/X0/M0_g N_GND!_X133/X0/M0_s
+ N_GND!_X26/M0_b N_18 L=1.8e-07 W=5e-07 AD=1.4e-13 AS=2.85e-13 PD=5.6e-07
+ PS=1.64e-06
mX133/X0/M1 N_84_X133/X0/M1_d N_83_X133/X0/M1_g N_X133/X0/6_X133/X0/M1_s
+ N_GND!_X26/M0_b N_18 L=1.8e-07 W=5e-07 AD=3.025e-13 AS=1.4e-13 PD=1.71e-06
+ PS=5.6e-07
mX133/X0/M2 N_84_X133/X0/M2_d N_131_X133/X0/M2_g N_VDD!_X133/X0/M2_s
+ N_VDD!_X26/M1_b P_18 L=1.8e-07 W=5e-07 AD=1.4e-13 AS=2.85e-13 PD=5.6e-07
+ PS=1.64e-06
mX133/X0/M3 N_VDD!_X133/X0/M3_d N_83_X133/X0/M3_g N_84_X133/X0/M3_s
+ N_VDD!_X26/M1_b P_18 L=1.8e-07 W=5e-07 AD=3.025e-13 AS=1.4e-13 PD=1.71e-06
+ PS=5.6e-07
mX133/X1/M0 N_X133/X1/6_X133/X1/M0_d N_8_X133/X1/M0_g N_GND!_X133/X1/M0_s
+ N_GND!_X26/M0_b N_18 L=1.8e-07 W=5e-07 AD=1.4e-13 AS=2.85e-13 PD=5.6e-07
+ PS=1.64e-06
mX133/X1/M1 N_126_X133/X1/M1_d N_84_X133/X1/M1_g N_X133/X1/6_X133/X1/M1_s
+ N_GND!_X26/M0_b N_18 L=1.8e-07 W=5e-07 AD=3.025e-13 AS=1.4e-13 PD=1.71e-06
+ PS=5.6e-07
mX133/X1/M2 N_126_X133/X1/M2_d N_8_X133/X1/M2_g N_VDD!_X133/X1/M2_s
+ N_VDD!_X26/M1_b P_18 L=1.8e-07 W=5e-07 AD=1.4e-13 AS=2.85e-13 PD=5.6e-07
+ PS=1.64e-06
mX133/X1/M3 N_VDD!_X133/X1/M3_d N_84_X133/X1/M3_g N_126_X133/X1/M3_s
+ N_VDD!_X26/M1_b P_18 L=1.8e-07 W=5e-07 AD=3.025e-13 AS=1.4e-13 PD=1.71e-06
+ PS=5.6e-07
mX134/X0/M0 N_X134/X0/6_X134/X0/M0_d N_12_X134/X0/M0_g N_GND!_X134/X0/M0_s
+ N_GND!_X26/M0_b N_18 L=1.8e-07 W=5e-07 AD=1.4e-13 AS=2.85e-13 PD=5.6e-07
+ PS=1.64e-06
mX134/X0/M1 N_129_X134/X0/M1_d N_87_X134/X0/M1_g N_X134/X0/6_X134/X0/M1_s
+ N_GND!_X26/M0_b N_18 L=1.8e-07 W=5e-07 AD=3.025e-13 AS=1.4e-13 PD=1.71e-06
+ PS=5.6e-07
mX134/X0/M2 N_129_X134/X0/M2_d N_12_X134/X0/M2_g N_VDD!_X134/X0/M2_s
+ N_VDD!_X27/M1_b P_18 L=1.8e-07 W=5e-07 AD=1.4e-13 AS=2.85e-13 PD=5.6e-07
+ PS=1.64e-06
mX134/X0/M3 N_VDD!_X134/X0/M3_d N_87_X134/X0/M3_g N_129_X134/X0/M3_s
+ N_VDD!_X27/M1_b P_18 L=1.8e-07 W=5e-07 AD=3.025e-13 AS=1.4e-13 PD=1.71e-06
+ PS=5.6e-07
mX134/X1/M0 N_X134/X1/6_X134/X1/M0_d N_129_X134/X1/M0_g N_GND!_X134/X1/M0_s
+ N_GND!_X26/M0_b N_18 L=1.8e-07 W=5e-07 AD=1.4e-13 AS=2.85e-13 PD=5.6e-07
+ PS=1.64e-06
mX134/X1/M1 N_78_X134/X1/M1_d N_79_X134/X1/M1_g N_X134/X1/6_X134/X1/M1_s
+ N_GND!_X26/M0_b N_18 L=1.8e-07 W=5e-07 AD=3.025e-13 AS=1.4e-13 PD=1.71e-06
+ PS=5.6e-07
mX134/X1/M2 N_78_X134/X1/M2_d N_129_X134/X1/M2_g N_VDD!_X134/X1/M2_s
+ N_VDD!_X27/M1_b P_18 L=1.8e-07 W=5e-07 AD=1.4e-13 AS=2.85e-13 PD=5.6e-07
+ PS=1.64e-06
mX134/X1/M3 N_VDD!_X134/X1/M3_d N_79_X134/X1/M3_g N_78_X134/X1/M3_s
+ N_VDD!_X27/M1_b P_18 L=1.8e-07 W=5e-07 AD=3.025e-13 AS=1.4e-13 PD=1.71e-06
+ PS=5.6e-07
mX135/X0/M0 N_X135/X0/6_X135/X0/M0_d N_A[5]_X135/X0/M0_g N_GND!_X135/X0/M0_s
+ N_GND!_X26/M0_b N_18 L=1.8e-07 W=5e-07 AD=1.4e-13 AS=2.85e-13 PD=5.6e-07
+ PS=1.64e-06
mX135/X0/M1 N_130_X135/X0/M1_d N_9_X135/X0/M1_g N_X135/X0/6_X135/X0/M1_s
+ N_GND!_X26/M0_b N_18 L=1.8e-07 W=5e-07 AD=3.025e-13 AS=1.4e-13 PD=1.71e-06
+ PS=5.6e-07
mX135/X0/M2 N_130_X135/X0/M2_d N_A[5]_X135/X0/M2_g N_VDD!_X135/X0/M2_s
+ N_VDD!_X28/M1_b P_18 L=1.8e-07 W=5e-07 AD=1.4e-13 AS=2.85e-13 PD=5.6e-07
+ PS=1.64e-06
mX135/X0/M3 N_VDD!_X135/X0/M3_d N_9_X135/X0/M3_g N_130_X135/X0/M3_s
+ N_VDD!_X28/M1_b P_18 L=1.8e-07 W=5e-07 AD=3.025e-13 AS=1.4e-13 PD=1.71e-06
+ PS=5.6e-07
mX135/X1/M0 N_X135/X1/6_X135/X1/M0_d N_130_X135/X1/M0_g N_GND!_X135/X1/M0_s
+ N_GND!_X26/M0_b N_18 L=1.8e-07 W=5e-07 AD=1.4e-13 AS=2.85e-13 PD=5.6e-07
+ PS=1.64e-06
mX135/X1/M1 N_12_X135/X1/M1_d N_80_X135/X1/M1_g N_X135/X1/6_X135/X1/M1_s
+ N_GND!_X26/M0_b N_18 L=1.8e-07 W=5e-07 AD=3.025e-13 AS=1.4e-13 PD=1.71e-06
+ PS=5.6e-07
mX135/X1/M2 N_12_X135/X1/M2_d N_130_X135/X1/M2_g N_VDD!_X135/X1/M2_s
+ N_VDD!_X28/M1_b P_18 L=1.8e-07 W=5e-07 AD=1.4e-13 AS=2.85e-13 PD=5.6e-07
+ PS=1.64e-06
mX135/X1/M3 N_VDD!_X135/X1/M3_d N_80_X135/X1/M3_g N_12_X135/X1/M3_s
+ N_VDD!_X28/M1_b P_18 L=1.8e-07 W=5e-07 AD=3.025e-13 AS=1.4e-13 PD=1.71e-06
+ PS=5.6e-07
mX136/X0/M0 N_X136/X0/6_X136/X0/M0_d N_30_X136/X0/M0_g N_GND!_X136/X0/M0_s
+ N_GND!_X26/M0_b N_18 L=1.8e-07 W=5e-07 AD=1.4e-13 AS=2.85e-13 PD=5.6e-07
+ PS=1.64e-06
mX136/X0/M1 N_19_X136/X0/M1_d N_16_X136/X0/M1_g N_X136/X0/6_X136/X0/M1_s
+ N_GND!_X26/M0_b N_18 L=1.8e-07 W=5e-07 AD=3.025e-13 AS=1.4e-13 PD=1.71e-06
+ PS=5.6e-07
mX136/X0/M2 N_19_X136/X0/M2_d N_30_X136/X0/M2_g N_VDD!_X136/X0/M2_s
+ N_VDD!_X30/M1_b P_18 L=1.8e-07 W=5e-07 AD=1.4e-13 AS=2.85e-13 PD=5.6e-07
+ PS=1.64e-06
mX136/X0/M3 N_VDD!_X136/X0/M3_d N_16_X136/X0/M3_g N_19_X136/X0/M3_s
+ N_VDD!_X30/M1_b P_18 L=1.8e-07 W=5e-07 AD=3.025e-13 AS=1.4e-13 PD=1.71e-06
+ PS=5.6e-07
mX136/X1/M0 N_X136/X1/6_X136/X1/M0_d N_B[6]_X136/X1/M0_g N_GND!_X136/X1/M0_s
+ N_GND!_X26/M0_b N_18 L=1.8e-07 W=5e-07 AD=1.4e-13 AS=2.85e-13 PD=5.6e-07
+ PS=1.64e-06
mX136/X1/M1 N_14_X136/X1/M1_d N_16_X136/X1/M1_g N_X136/X1/6_X136/X1/M1_s
+ N_GND!_X26/M0_b N_18 L=1.8e-07 W=5e-07 AD=3.025e-13 AS=1.4e-13 PD=1.71e-06
+ PS=5.6e-07
mX136/X1/M2 N_14_X136/X1/M2_d N_B[6]_X136/X1/M2_g N_VDD!_X136/X1/M2_s
+ N_VDD!_X30/M1_b P_18 L=1.8e-07 W=5e-07 AD=1.4e-13 AS=2.85e-13 PD=5.6e-07
+ PS=1.64e-06
mX136/X1/M3 N_VDD!_X136/X1/M3_d N_16_X136/X1/M3_g N_14_X136/X1/M3_s
+ N_VDD!_X30/M1_b P_18 L=1.8e-07 W=5e-07 AD=3.025e-13 AS=1.4e-13 PD=1.71e-06
+ PS=5.6e-07
mX137/X0/M0 N_X137/X0/6_X137/X0/M0_d N_B[4]_X137/X0/M0_g N_GND!_X137/X0/M0_s
+ N_GND!_X26/M0_b N_18 L=1.8e-07 W=5e-07 AD=1.4e-13 AS=2.85e-13 PD=5.6e-07
+ PS=1.64e-06
mX137/X0/M1 N_3_X137/X0/M1_d N_89_X137/X0/M1_g N_X137/X0/6_X137/X0/M1_s
+ N_GND!_X26/M0_b N_18 L=1.8e-07 W=5e-07 AD=3.025e-13 AS=1.4e-13 PD=1.71e-06
+ PS=5.6e-07
mX137/X0/M2 N_3_X137/X0/M2_d N_B[4]_X137/X0/M2_g N_VDD!_X137/X0/M2_s
+ N_VDD!_X28/M1_b P_18 L=1.8e-07 W=5e-07 AD=1.4e-13 AS=2.85e-13 PD=5.6e-07
+ PS=1.64e-06
mX137/X0/M3 N_VDD!_X137/X0/M3_d N_89_X137/X0/M3_g N_3_X137/X0/M3_s
+ N_VDD!_X28/M1_b P_18 L=1.8e-07 W=5e-07 AD=3.025e-13 AS=1.4e-13 PD=1.71e-06
+ PS=5.6e-07
mX137/X1/M0 N_X137/X1/6_X137/X1/M0_d N_24_X137/X1/M0_g N_GND!_X137/X1/M0_s
+ N_GND!_X26/M0_b N_18 L=1.8e-07 W=5e-07 AD=1.4e-13 AS=2.85e-13 PD=5.6e-07
+ PS=1.64e-06
mX137/X1/M1 N_87_X137/X1/M1_d N_3_X137/X1/M1_g N_X137/X1/6_X137/X1/M1_s
+ N_GND!_X26/M0_b N_18 L=1.8e-07 W=5e-07 AD=3.025e-13 AS=1.4e-13 PD=1.71e-06
+ PS=5.6e-07
mX137/X1/M2 N_87_X137/X1/M2_d N_24_X137/X1/M2_g N_VDD!_X137/X1/M2_s
+ N_VDD!_X28/M1_b P_18 L=1.8e-07 W=5e-07 AD=1.4e-13 AS=2.85e-13 PD=5.6e-07
+ PS=1.64e-06
mX137/X1/M3 N_VDD!_X137/X1/M3_d N_3_X137/X1/M3_g N_87_X137/X1/M3_s
+ N_VDD!_X28/M1_b P_18 L=1.8e-07 W=5e-07 AD=3.025e-13 AS=1.4e-13 PD=1.71e-06
+ PS=5.6e-07
mX138/X0/M0 N_X138/X0/6_X138/X0/M0_d N_101_X138/X0/M0_g N_GND!_X138/X0/M0_s
+ N_GND!_X26/M0_b N_18 L=1.8e-07 W=5e-07 AD=1.4e-13 AS=2.85e-13 PD=5.6e-07
+ PS=1.64e-06
mX138/X0/M1 N_100_X138/X0/M1_d N_31_X138/X0/M1_g N_X138/X0/6_X138/X0/M1_s
+ N_GND!_X26/M0_b N_18 L=1.8e-07 W=5e-07 AD=3.025e-13 AS=1.4e-13 PD=1.71e-06
+ PS=5.6e-07
mX138/X0/M2 N_100_X138/X0/M2_d N_101_X138/X0/M2_g N_VDD!_X138/X0/M2_s
+ N_VDD!_X28/M1_b P_18 L=1.8e-07 W=5e-07 AD=1.4e-13 AS=2.85e-13 PD=5.6e-07
+ PS=1.64e-06
mX138/X0/M3 N_VDD!_X138/X0/M3_d N_31_X138/X0/M3_g N_100_X138/X0/M3_s
+ N_VDD!_X28/M1_b P_18 L=1.8e-07 W=5e-07 AD=3.025e-13 AS=1.4e-13 PD=1.71e-06
+ PS=5.6e-07
mX138/X1/M0 N_X138/X1/6_X138/X1/M0_d N_A[4]_X138/X1/M0_g N_GND!_X138/X1/M0_s
+ N_GND!_X26/M0_b N_18 L=1.8e-07 W=5e-07 AD=1.4e-13 AS=2.85e-13 PD=5.6e-07
+ PS=1.64e-06
mX138/X1/M1 N_24_X138/X1/M1_d N_29_X138/X1/M1_g N_X138/X1/6_X138/X1/M1_s
+ N_GND!_X26/M0_b N_18 L=1.8e-07 W=5e-07 AD=3.025e-13 AS=1.4e-13 PD=1.71e-06
+ PS=5.6e-07
mX138/X1/M2 N_24_X138/X1/M2_d N_A[4]_X138/X1/M2_g N_VDD!_X138/X1/M2_s
+ N_VDD!_X28/M1_b P_18 L=1.8e-07 W=5e-07 AD=1.4e-13 AS=2.85e-13 PD=5.6e-07
+ PS=1.64e-06
mX138/X1/M3 N_VDD!_X138/X1/M3_d N_29_X138/X1/M3_g N_24_X138/X1/M3_s
+ N_VDD!_X28/M1_b P_18 L=1.8e-07 W=5e-07 AD=3.025e-13 AS=1.4e-13 PD=1.71e-06
+ PS=5.6e-07
mX139/X0/M0 N_X139/X0/6_X139/X0/M0_d N_100_X139/X0/M0_g N_GND!_X139/X0/M0_s
+ N_GND!_X26/M0_b N_18 L=1.8e-07 W=5e-07 AD=1.4e-13 AS=2.85e-13 PD=5.6e-07
+ PS=1.64e-06
mX139/X0/M1 N_134_X139/X0/M1_d N_29_X139/X0/M1_g N_X139/X0/6_X139/X0/M1_s
+ N_GND!_X26/M0_b N_18 L=1.8e-07 W=5e-07 AD=3.025e-13 AS=1.4e-13 PD=1.71e-06
+ PS=5.6e-07
mX139/X0/M2 N_134_X139/X0/M2_d N_100_X139/X0/M2_g N_VDD!_X139/X0/M2_s
+ N_VDD!_X33/M1_b P_18 L=1.8e-07 W=5e-07 AD=1.4e-13 AS=2.85e-13 PD=5.6e-07
+ PS=1.64e-06
mX139/X0/M3 N_VDD!_X139/X0/M3_d N_29_X139/X0/M3_g N_134_X139/X0/M3_s
+ N_VDD!_X33/M1_b P_18 L=1.8e-07 W=5e-07 AD=3.025e-13 AS=1.4e-13 PD=1.71e-06
+ PS=5.6e-07
mX139/X1/M0 N_X139/X1/6_X139/X1/M0_d N_134_X139/X1/M0_g N_GND!_X139/X1/M0_s
+ N_GND!_X26/M0_b N_18 L=1.8e-07 W=5e-07 AD=1.4e-13 AS=2.85e-13 PD=5.6e-07
+ PS=1.64e-06
mX139/X1/M1 N_96_X139/X1/M1_d N_94_X139/X1/M1_g N_X139/X1/6_X139/X1/M1_s
+ N_GND!_X26/M0_b N_18 L=1.8e-07 W=5e-07 AD=3.025e-13 AS=1.4e-13 PD=1.71e-06
+ PS=5.6e-07
mX139/X1/M2 N_96_X139/X1/M2_d N_134_X139/X1/M2_g N_VDD!_X139/X1/M2_s
+ N_VDD!_X33/M1_b P_18 L=1.8e-07 W=5e-07 AD=1.4e-13 AS=2.85e-13 PD=5.6e-07
+ PS=1.64e-06
mX139/X1/M3 N_VDD!_X139/X1/M3_d N_94_X139/X1/M3_g N_96_X139/X1/M3_s
+ N_VDD!_X33/M1_b P_18 L=1.8e-07 W=5e-07 AD=3.025e-13 AS=1.4e-13 PD=1.71e-06
+ PS=5.6e-07
mX140/X0/M0 N_X140/X0/6_X140/X0/M0_d N_B[7]_X140/X0/M0_g N_GND!_X140/X0/M0_s
+ N_GND!_X26/M0_b N_18 L=1.8e-07 W=5e-07 AD=1.4e-13 AS=2.85e-13 PD=5.6e-07
+ PS=1.64e-06
mX140/X0/M1 N_37_X140/X0/M1_d N_35_X140/X0/M1_g N_X140/X0/6_X140/X0/M1_s
+ N_GND!_X26/M0_b N_18 L=1.8e-07 W=5e-07 AD=3.025e-13 AS=1.4e-13 PD=1.71e-06
+ PS=5.6e-07
mX140/X0/M2 N_37_X140/X0/M2_d N_B[7]_X140/X0/M2_g N_VDD!_X140/X0/M2_s
+ N_VDD!_X26/M1_b P_18 L=1.8e-07 W=5e-07 AD=1.4e-13 AS=2.85e-13 PD=5.6e-07
+ PS=1.64e-06
mX140/X0/M3 N_VDD!_X140/X0/M3_d N_35_X140/X0/M3_g N_37_X140/X0/M3_s
+ N_VDD!_X26/M1_b P_18 L=1.8e-07 W=5e-07 AD=3.025e-13 AS=1.4e-13 PD=1.71e-06
+ PS=5.6e-07
mX140/X1/M0 N_X140/X1/6_X140/X1/M0_d N_33_X140/X1/M0_g N_GND!_X140/X1/M0_s
+ N_GND!_X26/M0_b N_18 L=1.8e-07 W=5e-07 AD=1.4e-13 AS=2.85e-13 PD=5.6e-07
+ PS=1.64e-06
mX140/X1/M1 N_COUT_X140/X1/M1_d N_37_X140/X1/M1_g N_X140/X1/6_X140/X1/M1_s
+ N_GND!_X26/M0_b N_18 L=1.8e-07 W=5e-07 AD=3.025e-13 AS=1.4e-13 PD=1.71e-06
+ PS=5.6e-07
mX140/X1/M2 N_COUT_X140/X1/M2_d N_33_X140/X1/M2_g N_VDD!_X140/X1/M2_s
+ N_VDD!_X26/M1_b P_18 L=1.8e-07 W=5e-07 AD=1.4e-13 AS=2.85e-13 PD=5.6e-07
+ PS=1.64e-06
mX140/X1/M3 N_VDD!_X140/X1/M3_d N_37_X140/X1/M3_g N_COUT_X140/X1/M3_s
+ N_VDD!_X26/M1_b P_18 L=1.8e-07 W=5e-07 AD=3.025e-13 AS=1.4e-13 PD=1.71e-06
+ PS=5.6e-07
mX141/X0/M0 N_X141/X0/6_X141/X0/M0_d N_A[3]_X141/X0/M0_g N_GND!_X141/X0/M0_s
+ N_GND!_X26/M0_b N_18 L=1.8e-07 W=5e-07 AD=1.4e-13 AS=2.85e-13 PD=5.6e-07
+ PS=1.64e-06
mX141/X0/M1 N_135_X141/X0/M1_d N_108_X141/X0/M1_g N_X141/X0/6_X141/X0/M1_s
+ N_GND!_X26/M0_b N_18 L=1.8e-07 W=5e-07 AD=3.025e-13 AS=1.4e-13 PD=1.71e-06
+ PS=5.6e-07
mX141/X0/M2 N_135_X141/X0/M2_d N_A[3]_X141/X0/M2_g N_VDD!_X141/X0/M2_s
+ N_VDD!_X28/M1_b P_18 L=1.8e-07 W=5e-07 AD=1.4e-13 AS=2.85e-13 PD=5.6e-07
+ PS=1.64e-06
mX141/X0/M3 N_VDD!_X141/X0/M3_d N_108_X141/X0/M3_g N_135_X141/X0/M3_s
+ N_VDD!_X28/M1_b P_18 L=1.8e-07 W=5e-07 AD=3.025e-13 AS=1.4e-13 PD=1.71e-06
+ PS=5.6e-07
mX141/X1/M0 N_X141/X1/6_X141/X1/M0_d N_135_X141/X1/M0_g N_GND!_X141/X1/M0_s
+ N_GND!_X26/M0_b N_18 L=1.8e-07 W=5e-07 AD=1.4e-13 AS=2.85e-13 PD=5.6e-07
+ PS=1.64e-06
mX141/X1/M1 N_29_X141/X1/M1_d N_103_X141/X1/M1_g N_X141/X1/6_X141/X1/M1_s
+ N_GND!_X26/M0_b N_18 L=1.8e-07 W=5e-07 AD=3.025e-13 AS=1.4e-13 PD=1.71e-06
+ PS=5.6e-07
mX141/X1/M2 N_29_X141/X1/M2_d N_135_X141/X1/M2_g N_VDD!_X141/X1/M2_s
+ N_VDD!_X28/M1_b P_18 L=1.8e-07 W=5e-07 AD=1.4e-13 AS=2.85e-13 PD=5.6e-07
+ PS=1.64e-06
mX141/X1/M3 N_VDD!_X141/X1/M3_d N_103_X141/X1/M3_g N_29_X141/X1/M3_s
+ N_VDD!_X28/M1_b P_18 L=1.8e-07 W=5e-07 AD=3.025e-13 AS=1.4e-13 PD=1.71e-06
+ PS=5.6e-07
mX142/X0/M0 N_X142/X0/6_X142/X0/M0_d N_110_X142/X0/M0_g N_GND!_X142/X0/M0_s
+ N_GND!_X26/M0_b N_18 L=1.8e-07 W=5e-07 AD=1.4e-13 AS=2.85e-13 PD=5.6e-07
+ PS=1.64e-06
mX142/X0/M1 N_136_X142/X0/M1_d N_69_X142/X0/M1_g N_X142/X0/6_X142/X0/M1_s
+ N_GND!_X26/M0_b N_18 L=1.8e-07 W=5e-07 AD=3.025e-13 AS=1.4e-13 PD=1.71e-06
+ PS=5.6e-07
mX142/X0/M2 N_136_X142/X0/M2_d N_110_X142/X0/M2_g N_VDD!_X142/X0/M2_s
+ N_VDD!_X33/M1_b P_18 L=1.8e-07 W=5e-07 AD=1.4e-13 AS=2.85e-13 PD=5.6e-07
+ PS=1.64e-06
mX142/X0/M3 N_VDD!_X142/X0/M3_d N_69_X142/X0/M3_g N_136_X142/X0/M3_s
+ N_VDD!_X33/M1_b P_18 L=1.8e-07 W=5e-07 AD=3.025e-13 AS=1.4e-13 PD=1.71e-06
+ PS=5.6e-07
mX142/X1/M0 N_X142/X1/6_X142/X1/M0_d N_136_X142/X1/M0_g N_GND!_X142/X1/M0_s
+ N_GND!_X26/M0_b N_18 L=1.8e-07 W=5e-07 AD=1.4e-13 AS=2.85e-13 PD=5.6e-07
+ PS=1.64e-06
mX142/X1/M1 N_104_X142/X1/M1_d N_39_X142/X1/M1_g N_X142/X1/6_X142/X1/M1_s
+ N_GND!_X26/M0_b N_18 L=1.8e-07 W=5e-07 AD=3.025e-13 AS=1.4e-13 PD=1.71e-06
+ PS=5.6e-07
mX142/X1/M2 N_104_X142/X1/M2_d N_136_X142/X1/M2_g N_VDD!_X142/X1/M2_s
+ N_VDD!_X33/M1_b P_18 L=1.8e-07 W=5e-07 AD=1.4e-13 AS=2.85e-13 PD=5.6e-07
+ PS=1.64e-06
mX142/X1/M3 N_VDD!_X142/X1/M3_d N_39_X142/X1/M3_g N_104_X142/X1/M3_s
+ N_VDD!_X33/M1_b P_18 L=1.8e-07 W=5e-07 AD=3.025e-13 AS=1.4e-13 PD=1.71e-06
+ PS=5.6e-07
mX143/X0/M0 N_X143/X0/6_X143/X0/M0_d N_B[2]_X143/X0/M0_g N_GND!_X143/X0/M0_s
+ N_GND!_X26/M0_b N_18 L=1.8e-07 W=5e-07 AD=1.4e-13 AS=2.85e-13 PD=5.6e-07
+ PS=1.64e-06
mX143/X0/M1 N_116_X143/X0/M1_d N_61_X143/X0/M1_g N_X143/X0/6_X143/X0/M1_s
+ N_GND!_X26/M0_b N_18 L=1.8e-07 W=5e-07 AD=3.025e-13 AS=1.4e-13 PD=1.71e-06
+ PS=5.6e-07
mX143/X0/M2 N_116_X143/X0/M2_d N_B[2]_X143/X0/M2_g N_VDD!_X143/X0/M2_s
+ N_VDD!_X33/M1_b P_18 L=1.8e-07 W=5e-07 AD=1.4e-13 AS=2.85e-13 PD=5.6e-07
+ PS=1.64e-06
mX143/X0/M3 N_VDD!_X143/X0/M3_d N_61_X143/X0/M3_g N_116_X143/X0/M3_s
+ N_VDD!_X33/M1_b P_18 L=1.8e-07 W=5e-07 AD=3.025e-13 AS=1.4e-13 PD=1.71e-06
+ PS=5.6e-07
mX143/X1/M0 N_X143/X1/6_X143/X1/M0_d N_B[2]_X143/X1/M0_g N_GND!_X143/X1/M0_s
+ N_GND!_X26/M0_b N_18 L=1.8e-07 W=5e-07 AD=1.4e-13 AS=2.85e-13 PD=5.6e-07
+ PS=1.64e-06
mX143/X1/M1 N_57_X143/X1/M1_d N_114_X143/X1/M1_g N_X143/X1/6_X143/X1/M1_s
+ N_GND!_X26/M0_b N_18 L=1.8e-07 W=5e-07 AD=3.025e-13 AS=1.4e-13 PD=1.71e-06
+ PS=5.6e-07
mX143/X1/M2 N_57_X143/X1/M2_d N_B[2]_X143/X1/M2_g N_VDD!_X143/X1/M2_s
+ N_VDD!_X33/M1_b P_18 L=1.8e-07 W=5e-07 AD=1.4e-13 AS=2.85e-13 PD=5.6e-07
+ PS=1.64e-06
mX143/X1/M3 N_VDD!_X143/X1/M3_d N_114_X143/X1/M3_g N_57_X143/X1/M3_s
+ N_VDD!_X33/M1_b P_18 L=1.8e-07 W=5e-07 AD=3.025e-13 AS=1.4e-13 PD=1.71e-06
+ PS=5.6e-07
*
.include "RCA8.pex.sp.RCA8.pxi"
*
.ends
*
*

************************************************************************
XRCA8 GND! VDD! CIN A[3] SUM[7] B[5] A[6] B[6] A[5] A[7] SUM[4] SUM[6]
+ B[7] B[3] SUM[1] A[0] B[2] B[1] A[2] A[1] SUM[0] SUM[2] SUM[5] B[4] A[4] COUT
+ B[0] SUM[3] RCA8
.LIB '/home/2023_VLSI_83/cic018.l' TT
.option
+ post
+accurate=1
+ dcstep=1
+ NUMDGT=10
+ MEASDGT=10
.PARAM CL = 0p
C0 SUM[7] 0 CL
v0 vdd! 0 dc 1.8
v1 gnd! 0 dc 0
vA[8] A[8] 0 dc 1.8
vA[7] A[7] 0 dc 1.8
vA[6] A[6] 0 dc 1.8
vA[5] A[5] 0 dc 1.8
vA[4] A[4] 0 dc 1.8
vA[3] A[3] 0 dc 1.8
vA[2] A[2] 0 dc 1.8
vA[1] A[1] 0 dc 1.8
vA[0] A[0] 0 dc 1.8
vB[8] B[8] 0 dc 0
vB[7] B[7] 0 dc 0
vB[6] B[6] 0 dc 0
vB[5] B[5] 0 dc 0
vB[4] B[4] 0 dc 0
vB[3] B[3] 0 dc 0
vB[2] B[2] 0 dc 0
vB[1] B[1] 0 dc 0
vB[0] B[0] 0 dc 0
vCin Cin 0 pulse(0v 1.8v 0n 0.03n 0.03n 499.97n 1000n)
.MEAS TRAN Tr trig v(SUM[7]) val = 0.1*1.8 rise = 3 targ v(SUM[7]) val = 0.9*1.8 rise = 3
.MEAS TRAN Tf trig v(SUM[7]) val = 0.9*1.8 fall = 3 targ v(SUM[7]) val = 0.1*1.8 fall = 3
.OPTION post
.OP
.TEMP 25
.TRAN 0.1n 10000n
.END
